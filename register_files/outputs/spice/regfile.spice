* NGSPICE file created from regfile.ext - technology: sky130A

* Black-box entry subcircuit for sky130_fd_sc_hd__decap_3 abstract view
.subckt sky130_fd_sc_hd__decap_3 VGND VNB VPB VPWR
.ends

* Black-box entry subcircuit for sky130_fd_sc_hd__fill_1 abstract view
.subckt sky130_fd_sc_hd__fill_1 VGND VNB VPB VPWR
.ends

* Black-box entry subcircuit for sky130_fd_sc_hd__fill_2 abstract view
.subckt sky130_fd_sc_hd__fill_2 VGND VNB VPB VPWR
.ends

* Black-box entry subcircuit for sky130_fd_sc_hd__buf_1 abstract view
.subckt sky130_fd_sc_hd__buf_1 A VGND VNB VPB VPWR X
.ends

* Black-box entry subcircuit for sky130_fd_sc_hd__dfrtp_1 abstract view
.subckt sky130_fd_sc_hd__dfrtp_1 CLK D RESET_B VGND VNB VPB VPWR Q
.ends

* Black-box entry subcircuit for sky130_fd_sc_hd__tapvpwrvgnd_1 abstract view
.subckt sky130_fd_sc_hd__tapvpwrvgnd_1 VGND VPWR
.ends

* Black-box entry subcircuit for sky130_fd_sc_hd__nand2_1 abstract view
.subckt sky130_fd_sc_hd__nand2_1 A B VGND VNB VPB VPWR Y
.ends

* Black-box entry subcircuit for sky130_fd_sc_hd__a221o_1 abstract view
.subckt sky130_fd_sc_hd__a221o_1 A1 A2 B1 B2 C1 VGND VNB VPB VPWR X
.ends

* Black-box entry subcircuit for sky130_fd_sc_hd__mux2_1 abstract view
.subckt sky130_fd_sc_hd__mux2_1 A0 A1 S VGND VNB VPB VPWR X
.ends

* Black-box entry subcircuit for sky130_fd_sc_hd__buf_2 abstract view
.subckt sky130_fd_sc_hd__buf_2 A VGND VNB VPB VPWR X
.ends

* Black-box entry subcircuit for sky130_fd_sc_hd__a22o_1 abstract view
.subckt sky130_fd_sc_hd__a22o_1 A1 A2 B1 B2 VGND VNB VPB VPWR X
.ends

* Black-box entry subcircuit for sky130_fd_sc_hd__and4b_2 abstract view
.subckt sky130_fd_sc_hd__and4b_2 A_N B C D VGND VNB VPB VPWR X
.ends

* Black-box entry subcircuit for sky130_fd_sc_hd__clkbuf_4 abstract view
.subckt sky130_fd_sc_hd__clkbuf_4 A VGND VNB VPB VPWR X
.ends

* Black-box entry subcircuit for sky130_fd_sc_hd__o21ba_1 abstract view
.subckt sky130_fd_sc_hd__o21ba_1 A1 A2 B1_N VGND VNB VPB VPWR X
.ends

* Black-box entry subcircuit for sky130_fd_sc_hd__clkbuf_2 abstract view
.subckt sky130_fd_sc_hd__clkbuf_2 A VGND VNB VPB VPWR X
.ends

* Black-box entry subcircuit for sky130_fd_sc_hd__nand2_2 abstract view
.subckt sky130_fd_sc_hd__nand2_2 A B VGND VNB VPB VPWR Y
.ends

* Black-box entry subcircuit for sky130_fd_sc_hd__or3_1 abstract view
.subckt sky130_fd_sc_hd__or3_1 A B C VGND VNB VPB VPWR X
.ends

* Black-box entry subcircuit for sky130_fd_sc_hd__and4bb_2 abstract view
.subckt sky130_fd_sc_hd__and4bb_2 A_N B_N C D VGND VNB VPB VPWR X
.ends

* Black-box entry subcircuit for sky130_fd_sc_hd__a2111o_1 abstract view
.subckt sky130_fd_sc_hd__a2111o_1 A1 A2 B1 C1 D1 VGND VNB VPB VPWR X
.ends

* Black-box entry subcircuit for sky130_fd_sc_hd__nor4b_1 abstract view
.subckt sky130_fd_sc_hd__nor4b_1 A B C D_N VGND VNB VPB VPWR Y
.ends

* Black-box entry subcircuit for sky130_fd_sc_hd__dlymetal6s2s_1 abstract view
.subckt sky130_fd_sc_hd__dlymetal6s2s_1 A VGND VNB VPB VPWR X
.ends

* Black-box entry subcircuit for sky130_fd_sc_hd__and3_2 abstract view
.subckt sky130_fd_sc_hd__and3_2 A B C VGND VNB VPB VPWR X
.ends

* Black-box entry subcircuit for sky130_fd_sc_hd__and3b_2 abstract view
.subckt sky130_fd_sc_hd__and3b_2 A_N B C VGND VNB VPB VPWR X
.ends

* Black-box entry subcircuit for sky130_fd_sc_hd__clkbuf_1 abstract view
.subckt sky130_fd_sc_hd__clkbuf_1 A VGND VNB VPB VPWR X
.ends

* Black-box entry subcircuit for sky130_fd_sc_hd__and4_1 abstract view
.subckt sky130_fd_sc_hd__and4_1 A B C D VGND VNB VPB VPWR X
.ends

* Black-box entry subcircuit for sky130_fd_sc_hd__a211o_1 abstract view
.subckt sky130_fd_sc_hd__a211o_1 A1 A2 B1 C1 VGND VNB VPB VPWR X
.ends

* Black-box entry subcircuit for sky130_fd_sc_hd__and4bb_1 abstract view
.subckt sky130_fd_sc_hd__and4bb_1 A_N B_N C D VGND VNB VPB VPWR X
.ends

* Black-box entry subcircuit for sky130_fd_sc_hd__or4_2 abstract view
.subckt sky130_fd_sc_hd__or4_2 A B C D VGND VNB VPB VPWR X
.ends

* Black-box entry subcircuit for sky130_fd_sc_hd__nor4_1 abstract view
.subckt sky130_fd_sc_hd__nor4_1 A B C D VGND VNB VPB VPWR Y
.ends

* Black-box entry subcircuit for sky130_fd_sc_hd__o22a_1 abstract view
.subckt sky130_fd_sc_hd__o22a_1 A1 A2 B1 B2 VGND VNB VPB VPWR X
.ends

* Black-box entry subcircuit for sky130_fd_sc_hd__nor2_1 abstract view
.subckt sky130_fd_sc_hd__nor2_1 A B VGND VNB VPB VPWR Y
.ends

.subckt regfile addr[0] addr[1] addr[2] addr[3] clk nrst rdata[0] rdata[1] rdata[2]
+ rdata[3] vccd vssd wdata[0] wdata[1] wdata[2] wdata[3] we
XFILLER_13_133 vssd vssd vccd vccd sky130_fd_sc_hd__decap_3
XFILLER_26_85 vssd vssd vccd vccd sky130_fd_sc_hd__fill_1
XFILLER_3_12 vssd vssd vccd vccd sky130_fd_sc_hd__decap_3
XFILLER_9_137 vssd vssd vccd vccd sky130_fd_sc_hd__fill_2
Xwire18 _075_ vssd vssd vccd vccd net18 sky130_fd_sc_hd__buf_1
X_294_ net42 _012_ net33 vssd vssd vccd vccd regs\[1\]\[0\] sky130_fd_sc_hd__dfrtp_1
XTAP_TAPCELL_ROW_15_106 vssd vccd sky130_fd_sc_hd__tapvpwrvgnd_1
XFILLER_8_170 vssd vssd vccd vccd sky130_fd_sc_hd__fill_2
XTAP_TAPCELL_ROW_12_98 vssd vccd sky130_fd_sc_hd__tapvpwrvgnd_1
XFILLER_10_169 vssd vssd vccd vccd sky130_fd_sc_hd__decap_3
XFILLER_12_43 vssd vssd vccd vccd sky130_fd_sc_hd__decap_3
XFILLER_6_129 vssd vssd vccd vccd sky130_fd_sc_hd__decap_3
X_346_ net35 _064_ net26 vssd vssd vccd vccd regs\[14\]\[0\] sky130_fd_sc_hd__dfrtp_1
XFILLER_5_162 vssd vssd vccd vccd sky130_fd_sc_hd__decap_3
X_277_ net52 _091_ vssd vssd vccd vccd _140_ sky130_fd_sc_hd__nand2_1
XFILLER_23_64 vssd vssd vccd vccd sky130_fd_sc_hd__decap_3
XFILLER_23_97 vssd vssd vccd vccd sky130_fd_sc_hd__decap_3
X_200_ regs\[7\]\[3\] _070_ _071_ regs\[1\]\[3\] _119_ vssd vssd vccd vccd _120_ sky130_fd_sc_hd__a221o_1
XFILLER_0_24 vssd vssd vccd vccd sky130_fd_sc_hd__decap_3
XFILLER_0_35 vssd vssd vccd vccd sky130_fd_sc_hd__decap_3
XFILLER_0_57 vssd vssd vccd vccd sky130_fd_sc_hd__decap_3
XFILLER_17_9 vssd vssd vccd vccd sky130_fd_sc_hd__fill_1
XFILLER_2_165 vssd vssd vccd vccd sky130_fd_sc_hd__decap_3
XFILLER_9_66 vssd vssd vccd vccd sky130_fd_sc_hd__decap_3
X_329_ net36 _047_ net27 vssd vssd vccd vccd regs\[9\]\[3\] sky130_fd_sc_hd__dfrtp_1
XFILLER_15_6 vssd vssd vccd vccd sky130_fd_sc_hd__decap_3
XFILLER_18_75 vssd vssd vccd vccd sky130_fd_sc_hd__decap_3
XTAP_TAPCELL_ROW_5_78 vssd vccd sky130_fd_sc_hd__tapvpwrvgnd_1
XFILLER_20_43 vssd vssd vccd vccd sky130_fd_sc_hd__decap_3
XFILLER_28_150 vssd vssd vccd vccd sky130_fd_sc_hd__decap_3
XFILLER_6_56 vssd vssd vccd vccd sky130_fd_sc_hd__decap_3
XFILLER_6_67 vssd vssd vccd vccd sky130_fd_sc_hd__decap_3
XFILLER_15_54 vssd vssd vccd vccd sky130_fd_sc_hd__fill_2
XFILLER_16_131 vssd vssd vccd vccd sky130_fd_sc_hd__decap_3
XTAP_TAPCELL_ROW_2_68 vssd vccd sky130_fd_sc_hd__tapvpwrvgnd_1
XTAP_TAPCELL_ROW_18_115 vssd vccd sky130_fd_sc_hd__tapvpwrvgnd_1
XFILLER_22_167 vssd vssd vccd vccd sky130_fd_sc_hd__decap_3
XFILLER_26_42 vssd vssd vccd vccd sky130_fd_sc_hd__decap_3
XFILLER_9_116 vssd vssd vccd vccd sky130_fd_sc_hd__fill_1
X_293_ net42 _011_ net33 vssd vssd vccd vccd regs\[0\]\[3\] sky130_fd_sc_hd__dfrtp_1
XTAP_TAPCELL_ROW_15_107 vssd vccd sky130_fd_sc_hd__tapvpwrvgnd_1
XTAP_TAPCELL_ROW_12_99 vssd vccd sky130_fd_sc_hd__tapvpwrvgnd_1
XFILLER_6_119 vssd vssd vccd vccd sky130_fd_sc_hd__fill_1
XTAP_TAPCELL_ROW_20_121 vssd vccd sky130_fd_sc_hd__tapvpwrvgnd_1
XFILLER_5_130 vssd vssd vccd vccd sky130_fd_sc_hd__decap_3
X_345_ net35 _063_ net26 vssd vssd vccd vccd regs\[13\]\[3\] sky130_fd_sc_hd__dfrtp_1
X_276_ net53 regs\[13\]\[3\] _139_ vssd vssd vccd vccd _063_ sky130_fd_sc_hd__mux2_1
XPHY_EDGE_ROW_12_Right_12 vssd vssd vccd vccd sky130_fd_sc_hd__decap_3
XPHY_EDGE_ROW_21_Right_21 vssd vssd vccd vccd sky130_fd_sc_hd__decap_3
XFILLER_0_69 vssd vssd vccd vccd sky130_fd_sc_hd__decap_3
XFILLER_2_111 vssd vssd vccd vccd sky130_fd_sc_hd__decap_3
XFILLER_9_23 vssd vssd vccd vccd sky130_fd_sc_hd__decap_3
X_328_ net35 _046_ net26 vssd vssd vccd vccd regs\[9\]\[2\] sky130_fd_sc_hd__dfrtp_1
X_259_ net23 regs\[10\]\[1\] _136_ vssd vssd vccd vccd _049_ sky130_fd_sc_hd__mux2_1
XFILLER_18_21 vssd vssd vccd vccd sky130_fd_sc_hd__decap_3
XFILLER_18_32 vssd vssd vccd vccd sky130_fd_sc_hd__decap_3
XPHY_EDGE_ROW_8_Left_37 vssd vssd vccd vccd sky130_fd_sc_hd__decap_3
XFILLER_20_55 vssd vssd vccd vccd sky130_fd_sc_hd__decap_3
XFILLER_19_151 vssd vssd vccd vccd sky130_fd_sc_hd__decap_3
XFILLER_28_162 vssd vssd vccd vccd sky130_fd_sc_hd__decap_3
XFILLER_6_24 vssd vssd vccd vccd sky130_fd_sc_hd__decap_3
XFILLER_6_79 vssd vssd vccd vccd sky130_fd_sc_hd__decap_3
XFILLER_25_110 vssd vssd vccd vccd sky130_fd_sc_hd__fill_2
XFILLER_25_165 vssd vssd vccd vccd sky130_fd_sc_hd__decap_3
XPHY_EDGE_ROW_6_Right_6 vssd vssd vccd vccd sky130_fd_sc_hd__decap_3
XFILLER_16_110 vssd vssd vccd vccd sky130_fd_sc_hd__fill_1
XTAP_TAPCELL_ROW_2_69 vssd vccd sky130_fd_sc_hd__tapvpwrvgnd_1
XTAP_TAPCELL_ROW_18_116 vssd vccd sky130_fd_sc_hd__tapvpwrvgnd_1
XFILLER_22_102 vssd vssd vccd vccd sky130_fd_sc_hd__fill_1
XFILLER_22_135 vssd vssd vccd vccd sky130_fd_sc_hd__decap_3
XFILLER_22_146 vssd vssd vccd vccd sky130_fd_sc_hd__decap_3
XFILLER_13_146 vssd vssd vccd vccd sky130_fd_sc_hd__fill_2
XFILLER_26_21 vssd vssd vccd vccd sky130_fd_sc_hd__decap_3
XFILLER_26_54 vssd vssd vccd vccd sky130_fd_sc_hd__fill_2
XFILLER_26_76 vssd vssd vccd vccd sky130_fd_sc_hd__decap_3
XFILLER_26_98 vssd vssd vccd vccd sky130_fd_sc_hd__decap_3
XFILLER_7_9 vssd vssd vccd vccd sky130_fd_sc_hd__decap_3
XFILLER_9_106 vssd vssd vccd vccd sky130_fd_sc_hd__decap_3
X_292_ net42 _010_ net33 vssd vssd vccd vccd regs\[0\]\[2\] sky130_fd_sc_hd__dfrtp_1
XTAP_TAPCELL_ROW_23_130 vssd vccd sky130_fd_sc_hd__tapvpwrvgnd_1
XTAP_TAPCELL_ROW_15_108 vssd vccd sky130_fd_sc_hd__tapvpwrvgnd_1
XFILLER_3_47 vssd vssd vccd vccd sky130_fd_sc_hd__decap_3
XFILLER_3_69 vssd vssd vccd vccd sky130_fd_sc_hd__decap_3
XFILLER_10_138 vssd vssd vccd vccd sky130_fd_sc_hd__fill_2
XTAP_TAPCELL_ROW_20_122 vssd vccd sky130_fd_sc_hd__tapvpwrvgnd_1
X_344_ net35 _062_ net26 vssd vssd vccd vccd regs\[13\]\[2\] sky130_fd_sc_hd__dfrtp_1
X_275_ net20 regs\[13\]\[2\] _139_ vssd vssd vccd vccd _062_ sky130_fd_sc_hd__mux2_1
XFILLER_0_15 vssd vssd vccd vccd sky130_fd_sc_hd__decap_3
XFILLER_0_48 vssd vssd vccd vccd sky130_fd_sc_hd__decap_3
XFILLER_23_55 vssd vssd vccd vccd sky130_fd_sc_hd__fill_1
XFILLER_23_88 vssd vssd vccd vccd sky130_fd_sc_hd__decap_3
XFILLER_2_156 vssd vssd vccd vccd sky130_fd_sc_hd__decap_3
XFILLER_3_3 vssd vssd vccd vccd sky130_fd_sc_hd__decap_3
XFILLER_9_57 vssd vssd vccd vccd sky130_fd_sc_hd__decap_3
X_327_ net36 _045_ net27 vssd vssd vccd vccd regs\[9\]\[1\] sky130_fd_sc_hd__dfrtp_1
X_258_ net24 regs\[10\]\[0\] _136_ vssd vssd vccd vccd _048_ sky130_fd_sc_hd__mux2_1
X_189_ regs\[7\]\[2\] _070_ _074_ regs\[4\]\[2\] _109_ vssd vssd vccd vccd _110_ sky130_fd_sc_hd__a221o_1
XPHY_EDGE_ROW_24_Left_53 vssd vssd vccd vccd sky130_fd_sc_hd__decap_3
XFILLER_18_44 vssd vssd vccd vccd sky130_fd_sc_hd__fill_2
XFILLER_18_66 vssd vssd vccd vccd sky130_fd_sc_hd__decap_3
XFILLER_22_9 vssd vssd vccd vccd sky130_fd_sc_hd__decap_3
XFILLER_1_91 vssd vssd vccd vccd sky130_fd_sc_hd__fill_1
XFILLER_20_12 vssd vssd vccd vccd sky130_fd_sc_hd__decap_3
XFILLER_20_6 vssd vssd vccd vccd sky130_fd_sc_hd__decap_3
XFILLER_28_141 vssd vssd vccd vccd sky130_fd_sc_hd__decap_3
XFILLER_6_36 vssd vssd vccd vccd sky130_fd_sc_hd__fill_2
XFILLER_19_163 vssd vssd vccd vccd sky130_fd_sc_hd__decap_3
XPHY_EDGE_ROW_11_Left_40 vssd vssd vccd vccd sky130_fd_sc_hd__decap_3
XFILLER_15_12 vssd vssd vccd vccd sky130_fd_sc_hd__decap_3
XFILLER_25_122 vssd vssd vccd vccd sky130_fd_sc_hd__decap_3
XTAP_TAPCELL_ROW_18_117 vssd vccd sky130_fd_sc_hd__tapvpwrvgnd_1
XFILLER_13_136 vssd vssd vccd vccd sky130_fd_sc_hd__fill_1
XFILLER_13_169 vssd vssd vccd vccd sky130_fd_sc_hd__decap_3
XFILLER_26_33 vssd vssd vccd vccd sky130_fd_sc_hd__decap_3
X_291_ net41 _009_ net32 vssd vssd vccd vccd regs\[0\]\[1\] sky130_fd_sc_hd__dfrtp_1
XTAP_TAPCELL_ROW_23_131 vssd vccd sky130_fd_sc_hd__tapvpwrvgnd_1
XFILLER_3_15 vssd vssd vccd vccd sky130_fd_sc_hd__decap_3
XFILLER_12_46 vssd vssd vccd vccd sky130_fd_sc_hd__decap_3
XTAP_TAPCELL_ROW_20_123 vssd vccd sky130_fd_sc_hd__tapvpwrvgnd_1
XFILLER_5_121 vssd vssd vccd vccd sky130_fd_sc_hd__decap_3
XFILLER_5_165 vssd vssd vccd vccd sky130_fd_sc_hd__decap_3
X_343_ net35 _061_ net26 vssd vssd vccd vccd regs\[13\]\[1\] sky130_fd_sc_hd__dfrtp_1
X_274_ net22 regs\[13\]\[1\] _139_ vssd vssd vccd vccd _061_ sky130_fd_sc_hd__mux2_1
XFILLER_0_27 vssd vssd vccd vccd sky130_fd_sc_hd__fill_1
XFILLER_23_12 vssd vssd vccd vccd sky130_fd_sc_hd__decap_3
XFILLER_23_67 vssd vssd vccd vccd sky130_fd_sc_hd__decap_3
XFILLER_2_135 vssd vssd vccd vccd sky130_fd_sc_hd__decap_3
XFILLER_2_168 vssd vssd vccd vccd sky130_fd_sc_hd__fill_1
X_326_ net35 _044_ net26 vssd vssd vccd vccd regs\[9\]\[0\] sky130_fd_sc_hd__dfrtp_1
X_257_ net52 _086_ vssd vssd vccd vccd _136_ sky130_fd_sc_hd__nand2_1
X_188_ regs\[3\]\[2\] _081_ _084_ regs\[8\]\[2\] net17 vssd vssd vccd vccd _109_ sky130_fd_sc_hd__a221o_1
XTAP_TAPCELL_ROW_9_90 vssd vccd sky130_fd_sc_hd__tapvpwrvgnd_1
XFILLER_18_12 vssd vssd vccd vccd sky130_fd_sc_hd__decap_3
XFILLER_18_78 vssd vssd vccd vccd sky130_fd_sc_hd__decap_3
XFILLER_15_9 vssd vssd vccd vccd sky130_fd_sc_hd__decap_3
X_309_ net40 _027_ net31 vssd vssd vccd vccd regs\[4\]\[3\] sky130_fd_sc_hd__dfrtp_1
XFILLER_20_46 vssd vssd vccd vccd sky130_fd_sc_hd__decap_3
XFILLER_28_153 vssd vssd vccd vccd sky130_fd_sc_hd__decap_3
XFILLER_6_59 vssd vssd vccd vccd sky130_fd_sc_hd__decap_3
XTAP_TAPCELL_ROW_6_80 vssd vccd sky130_fd_sc_hd__tapvpwrvgnd_1
XFILLER_15_57 vssd vssd vccd vccd sky130_fd_sc_hd__fill_1
XFILLER_25_101 vssd vssd vccd vccd sky130_fd_sc_hd__decap_3
XFILLER_25_134 vssd vssd vccd vccd sky130_fd_sc_hd__decap_3
Xoutput12 net12 vssd vssd vccd vccd rdata[0] sky130_fd_sc_hd__buf_2
XFILLER_11_3 vssd vssd vccd vccd sky130_fd_sc_hd__fill_1
XFILLER_16_101 vssd vssd vccd vccd sky130_fd_sc_hd__decap_3
XFILLER_16_134 vssd vssd vccd vccd sky130_fd_sc_hd__decap_3
XTAP_TAPCELL_ROW_26_140 vssd vccd sky130_fd_sc_hd__tapvpwrvgnd_1
XFILLER_26_12 vssd vssd vccd vccd sky130_fd_sc_hd__decap_3
XFILLER_26_45 vssd vssd vccd vccd sky130_fd_sc_hd__decap_3
X_290_ net42 _008_ net33 vssd vssd vccd vccd regs\[0\]\[0\] sky130_fd_sc_hd__dfrtp_1
XTAP_TAPCELL_ROW_23_132 vssd vccd sky130_fd_sc_hd__tapvpwrvgnd_1
XFILLER_8_141 vssd vssd vccd vccd sky130_fd_sc_hd__decap_3
XTAP_TAPCELL_ROW_3_70 vssd vccd sky130_fd_sc_hd__tapvpwrvgnd_1
XFILLER_5_111 vssd vssd vccd vccd sky130_fd_sc_hd__fill_1
XFILLER_5_133 vssd vssd vccd vccd sky130_fd_sc_hd__decap_3
X_342_ net35 _060_ net26 vssd vssd vccd vccd regs\[13\]\[0\] sky130_fd_sc_hd__dfrtp_1
X_273_ net24 regs\[13\]\[0\] _139_ vssd vssd vccd vccd _060_ sky130_fd_sc_hd__mux2_1
XFILLER_2_114 vssd vssd vccd vccd sky130_fd_sc_hd__fill_1
XFILLER_9_26 vssd vssd vccd vccd sky130_fd_sc_hd__decap_3
X_325_ net38 _043_ net29 vssd vssd vccd vccd regs\[8\]\[3\] sky130_fd_sc_hd__dfrtp_1
X_256_ net53 regs\[9\]\[3\] _135_ vssd vssd vccd vccd _047_ sky130_fd_sc_hd__mux2_1
X_187_ regs\[1\]\[2\] net19 net18 regs\[2\]\[2\] _107_ vssd vssd vccd vccd _108_ sky130_fd_sc_hd__a221o_1
XTAP_TAPCELL_ROW_0_60 vssd vccd sky130_fd_sc_hd__tapvpwrvgnd_1
XFILLER_18_24 vssd vssd vccd vccd sky130_fd_sc_hd__decap_3
XFILLER_18_35 vssd vssd vccd vccd sky130_fd_sc_hd__decap_3
X_308_ net41 _026_ net32 vssd vssd vccd vccd regs\[4\]\[2\] sky130_fd_sc_hd__dfrtp_1
X_239_ net22 regs\[6\]\[1\] _132_ vssd vssd vccd vccd _033_ sky130_fd_sc_hd__mux2_1
XFILLER_20_58 vssd vssd vccd vccd sky130_fd_sc_hd__decap_3
XFILLER_28_132 vssd vssd vccd vccd sky130_fd_sc_hd__decap_3
XFILLER_28_165 vssd vssd vccd vccd sky130_fd_sc_hd__decap_3
XTAP_TAPCELL_ROW_10_91 vssd vccd sky130_fd_sc_hd__tapvpwrvgnd_1
XFILLER_19_110 vssd vssd vccd vccd sky130_fd_sc_hd__fill_2
XFILLER_19_154 vssd vssd vccd vccd sky130_fd_sc_hd__decap_3
XFILLER_6_27 vssd vssd vccd vccd sky130_fd_sc_hd__fill_1
XTAP_TAPCELL_ROW_6_81 vssd vccd sky130_fd_sc_hd__tapvpwrvgnd_1
XFILLER_25_113 vssd vssd vccd vccd sky130_fd_sc_hd__decap_3
Xoutput13 net13 vssd vssd vccd vccd rdata[1] sky130_fd_sc_hd__buf_2
XPHY_EDGE_ROW_19_Right_19 vssd vssd vccd vccd sky130_fd_sc_hd__decap_3
XTAP_TAPCELL_ROW_26_141 vssd vccd sky130_fd_sc_hd__tapvpwrvgnd_1
XPHY_EDGE_ROW_28_Right_28 vssd vssd vccd vccd sky130_fd_sc_hd__decap_3
XFILLER_22_138 vssd vssd vccd vccd sky130_fd_sc_hd__fill_2
XFILLER_22_149 vssd vssd vccd vccd sky130_fd_sc_hd__decap_3
XFILLER_26_24 vssd vssd vccd vccd sky130_fd_sc_hd__decap_3
XFILLER_26_79 vssd vssd vccd vccd sky130_fd_sc_hd__fill_1
XFILLER_9_109 vssd vssd vccd vccd sky130_fd_sc_hd__decap_3
XFILLER_12_171 vssd vssd vccd vccd sky130_fd_sc_hd__fill_1
XFILLER_8_164 vssd vssd vccd vccd sky130_fd_sc_hd__decap_3
XTAP_TAPCELL_ROW_3_71 vssd vccd sky130_fd_sc_hd__tapvpwrvgnd_1
XFILLER_5_9 vssd vssd vccd vccd sky130_fd_sc_hd__decap_3
X_341_ net38 _059_ net29 vssd vssd vccd vccd regs\[12\]\[3\] sky130_fd_sc_hd__dfrtp_1
X_272_ net52 _088_ vssd vssd vccd vccd _139_ sky130_fd_sc_hd__nand2_1
XFILLER_5_156 vssd vssd vccd vccd sky130_fd_sc_hd__decap_3
XFILLER_0_18 vssd vssd vccd vccd sky130_fd_sc_hd__decap_3
XFILLER_0_29 vssd vssd vccd vccd sky130_fd_sc_hd__decap_3
XFILLER_2_159 vssd vssd vccd vccd sky130_fd_sc_hd__decap_3
XFILLER_3_6 vssd vssd vccd vccd sky130_fd_sc_hd__decap_3
X_324_ net41 _042_ net32 vssd vssd vccd vccd regs\[8\]\[2\] sky130_fd_sc_hd__dfrtp_1
X_255_ net20 regs\[9\]\[2\] _135_ vssd vssd vccd vccd _046_ sky130_fd_sc_hd__mux2_1
X_186_ regs\[5\]\[2\] _077_ _082_ regs\[6\]\[2\] vssd vssd vccd vccd _107_ sky130_fd_sc_hd__a22o_1
XTAP_TAPCELL_ROW_0_61 vssd vccd sky130_fd_sc_hd__tapvpwrvgnd_1
XFILLER_18_69 vssd vssd vccd vccd sky130_fd_sc_hd__decap_3
XFILLER_1_3 vssd vssd vccd vccd sky130_fd_sc_hd__decap_3
XFILLER_1_72 vssd vssd vccd vccd sky130_fd_sc_hd__decap_3
X_307_ net39 _025_ net30 vssd vssd vccd vccd regs\[4\]\[1\] sky130_fd_sc_hd__dfrtp_1
X_238_ net25 regs\[6\]\[0\] _132_ vssd vssd vccd vccd _032_ sky130_fd_sc_hd__mux2_1
X_169_ net47 net44 net55 net48 vssd vssd vccd vccd _092_ sky130_fd_sc_hd__and4b_2
XPHY_EDGE_ROW_28_Left_57 vssd vssd vccd vccd sky130_fd_sc_hd__decap_3
XFILLER_28_100 vssd vssd vccd vccd sky130_fd_sc_hd__decap_3
XFILLER_28_144 vssd vssd vccd vccd sky130_fd_sc_hd__decap_3
XTAP_TAPCELL_ROW_10_92 vssd vccd sky130_fd_sc_hd__tapvpwrvgnd_1
XFILLER_19_166 vssd vssd vccd vccd sky130_fd_sc_hd__fill_2
XFILLER_20_9 vssd vssd vccd vccd sky130_fd_sc_hd__decap_3
XFILLER_15_15 vssd vssd vccd vccd sky130_fd_sc_hd__decap_3
XFILLER_25_169 vssd vssd vccd vccd sky130_fd_sc_hd__decap_3
Xoutput14 net14 vssd vssd vccd vccd rdata[2] sky130_fd_sc_hd__buf_2
XPHY_EDGE_ROW_15_Left_44 vssd vssd vccd vccd sky130_fd_sc_hd__decap_3
XFILLER_26_36 vssd vssd vccd vccd sky130_fd_sc_hd__decap_3
XFILLER_12_150 vssd vssd vccd vccd sky130_fd_sc_hd__decap_3
XFILLER_8_110 vssd vssd vccd vccd sky130_fd_sc_hd__decap_3
XFILLER_8_132 vssd vssd vccd vccd sky130_fd_sc_hd__decap_3
XTAP_TAPCELL_ROW_3_72 vssd vccd sky130_fd_sc_hd__tapvpwrvgnd_1
XFILLER_12_27 vssd vssd vccd vccd sky130_fd_sc_hd__fill_1
XFILLER_12_49 vssd vssd vccd vccd sky130_fd_sc_hd__decap_3
XPHY_EDGE_ROW_0_Left_29 vssd vssd vccd vccd sky130_fd_sc_hd__decap_3
XFILLER_5_113 vssd vssd vccd vccd sky130_fd_sc_hd__fill_1
XFILLER_5_124 vssd vssd vccd vccd sky130_fd_sc_hd__decap_3
X_340_ net37 _058_ net28 vssd vssd vccd vccd regs\[12\]\[2\] sky130_fd_sc_hd__dfrtp_1
X_271_ net53 regs\[12\]\[3\] _138_ vssd vssd vccd vccd _059_ sky130_fd_sc_hd__mux2_1
XFILLER_23_15 vssd vssd vccd vccd sky130_fd_sc_hd__decap_3
XFILLER_4_50 vssd vssd vccd vccd sky130_fd_sc_hd__fill_1
XFILLER_4_61 vssd vssd vccd vccd sky130_fd_sc_hd__fill_2
XFILLER_4_72 vssd vssd vccd vccd sky130_fd_sc_hd__fill_2
XFILLER_4_83 vssd vssd vccd vccd sky130_fd_sc_hd__fill_1
XFILLER_2_138 vssd vssd vccd vccd sky130_fd_sc_hd__fill_2
X_323_ net41 _041_ net32 vssd vssd vccd vccd regs\[8\]\[1\] sky130_fd_sc_hd__dfrtp_1
X_254_ net22 regs\[9\]\[1\] _135_ vssd vssd vccd vccd _045_ sky130_fd_sc_hd__mux2_1
X_185_ net50 net13 _105_ _106_ vssd vssd vccd vccd _005_ sky130_fd_sc_hd__a22o_1
XTAP_TAPCELL_ROW_0_62 vssd vccd sky130_fd_sc_hd__tapvpwrvgnd_1
XFILLER_18_15 vssd vssd vccd vccd sky130_fd_sc_hd__decap_3
XFILLER_27_3 vssd vssd vccd vccd sky130_fd_sc_hd__decap_3
X_306_ net42 _024_ net33 vssd vssd vccd vccd regs\[4\]\[0\] sky130_fd_sc_hd__dfrtp_1
X_237_ net50 _082_ vssd vssd vccd vccd _132_ sky130_fd_sc_hd__nand2_1
X_168_ net55 net44 net47 net48 vssd vssd vccd vccd _091_ sky130_fd_sc_hd__and4b_2
XPHY_EDGE_ROW_3_Left_32 vssd vssd vccd vccd sky130_fd_sc_hd__decap_3
XFILLER_20_49 vssd vssd vccd vccd sky130_fd_sc_hd__decap_3
XFILLER_28_156 vssd vssd vccd vccd sky130_fd_sc_hd__decap_3
XFILLER_19_80 vssd vssd vccd vccd sky130_fd_sc_hd__decap_3
XTAP_TAPCELL_ROW_10_93 vssd vccd sky130_fd_sc_hd__tapvpwrvgnd_1
XFILLER_25_104 vssd vssd vccd vccd sky130_fd_sc_hd__decap_3
XFILLER_25_137 vssd vssd vccd vccd sky130_fd_sc_hd__decap_3
XFILLER_16_104 vssd vssd vccd vccd sky130_fd_sc_hd__decap_3
XFILLER_16_137 vssd vssd vccd vccd sky130_fd_sc_hd__decap_3
XPHY_EDGE_ROW_1_Right_1 vssd vssd vccd vccd sky130_fd_sc_hd__decap_3
Xoutput15 net15 vssd vssd vccd vccd rdata[3] sky130_fd_sc_hd__buf_2
XFILLER_26_15 vssd vssd vccd vccd sky130_fd_sc_hd__decap_3
XFILLER_26_48 vssd vssd vccd vccd sky130_fd_sc_hd__decap_3
XFILLER_7_94 vssd vssd vccd vccd sky130_fd_sc_hd__fill_1
XFILLER_8_122 vssd vssd vccd vccd sky130_fd_sc_hd__fill_1
XFILLER_8_144 vssd vssd vccd vccd sky130_fd_sc_hd__decap_3
XFILLER_5_136 vssd vssd vccd vccd sky130_fd_sc_hd__decap_3
XFILLER_5_169 vssd vssd vccd vccd sky130_fd_sc_hd__decap_3
X_270_ net20 regs\[12\]\[2\] _138_ vssd vssd vccd vccd _058_ sky130_fd_sc_hd__mux2_1
XFILLER_9_29 vssd vssd vccd vccd sky130_fd_sc_hd__fill_2
X_322_ net38 _040_ net29 vssd vssd vccd vccd regs\[8\]\[0\] sky130_fd_sc_hd__dfrtp_1
XFILLER_1_150 vssd vssd vccd vccd sky130_fd_sc_hd__decap_3
Xfanout50 net52 vssd vssd vccd vccd net50 sky130_fd_sc_hd__clkbuf_4
X_253_ net24 regs\[9\]\[0\] _135_ vssd vssd vccd vccd _044_ sky130_fd_sc_hd__mux2_1
X_184_ regs\[0\]\[1\] _079_ net50 vssd vssd vccd vccd _106_ sky130_fd_sc_hd__o21ba_1
XTAP_TAPCELL_ROW_0_63 vssd vccd sky130_fd_sc_hd__tapvpwrvgnd_1
XFILLER_18_27 vssd vssd vccd vccd sky130_fd_sc_hd__fill_1
XFILLER_18_38 vssd vssd vccd vccd sky130_fd_sc_hd__decap_3
X_305_ net39 _023_ net30 vssd vssd vccd vccd regs\[3\]\[3\] sky130_fd_sc_hd__dfrtp_1
X_236_ net54 regs\[5\]\[3\] _131_ vssd vssd vccd vccd _031_ sky130_fd_sc_hd__mux2_1
X_167_ regs\[13\]\[0\] _088_ _089_ regs\[9\]\[0\] vssd vssd vccd vccd _090_ sky130_fd_sc_hd__a22o_1
XFILLER_1_30 vssd vssd vccd vccd sky130_fd_sc_hd__decap_3
XFILLER_10_83 vssd vssd vccd vccd sky130_fd_sc_hd__fill_1
XFILLER_19_113 vssd vssd vccd vccd sky130_fd_sc_hd__decap_3
XFILLER_28_113 vssd vssd vccd vccd sky130_fd_sc_hd__fill_2
XFILLER_28_135 vssd vssd vccd vccd sky130_fd_sc_hd__decap_3
XFILLER_19_157 vssd vssd vccd vccd sky130_fd_sc_hd__decap_3
X_219_ net22 regs\[2\]\[1\] _128_ vssd vssd vccd vccd _017_ sky130_fd_sc_hd__mux2_1
XFILLER_15_39 vssd vssd vccd vccd sky130_fd_sc_hd__fill_2
XFILLER_25_116 vssd vssd vccd vccd sky130_fd_sc_hd__decap_3
XFILLER_26_27 vssd vssd vccd vccd sky130_fd_sc_hd__fill_1
XFILLER_7_51 vssd vssd vccd vccd sky130_fd_sc_hd__decap_3
XPHY_EDGE_ROW_15_Right_15 vssd vssd vccd vccd sky130_fd_sc_hd__decap_3
XPHY_EDGE_ROW_24_Right_24 vssd vssd vccd vccd sky130_fd_sc_hd__decap_3
XFILLER_16_82 vssd vssd vccd vccd sky130_fd_sc_hd__fill_2
XFILLER_8_101 vssd vssd vccd vccd sky130_fd_sc_hd__decap_3
XFILLER_8_167 vssd vssd vccd vccd sky130_fd_sc_hd__decap_3
XTAP_TAPCELL_ROW_14_103 vssd vccd sky130_fd_sc_hd__tapvpwrvgnd_1
XFILLER_5_159 vssd vssd vccd vccd sky130_fd_sc_hd__decap_3
XFILLER_4_85 vssd vssd vccd vccd sky130_fd_sc_hd__decap_3
XFILLER_3_9 vssd vssd vccd vccd sky130_fd_sc_hd__decap_3
XFILLER_13_83 vssd vssd vccd vccd sky130_fd_sc_hd__decap_3
XFILLER_1_162 vssd vssd vccd vccd sky130_fd_sc_hd__decap_3
X_321_ net41 _039_ net32 vssd vssd vccd vccd regs\[7\]\[3\] sky130_fd_sc_hd__dfrtp_1
Xfanout40 net43 vssd vssd vccd vccd net40 sky130_fd_sc_hd__buf_1
Xfanout51 net52 vssd vssd vccd vccd net51 sky130_fd_sc_hd__clkbuf_2
X_252_ net52 _089_ vssd vssd vccd vccd _135_ sky130_fd_sc_hd__nand2_2
X_183_ _102_ _103_ _104_ vssd vssd vccd vccd _105_ sky130_fd_sc_hd__or3_1
XFILLER_1_6 vssd vssd vccd vccd sky130_fd_sc_hd__decap_3
XFILLER_24_82 vssd vssd vccd vccd sky130_fd_sc_hd__fill_2
X_304_ net39 _022_ net30 vssd vssd vccd vccd regs\[3\]\[2\] sky130_fd_sc_hd__dfrtp_1
X_235_ net21 regs\[5\]\[2\] _131_ vssd vssd vccd vccd _030_ sky130_fd_sc_hd__mux2_1
XFILLER_1_75 vssd vssd vccd vccd sky130_fd_sc_hd__decap_3
XFILLER_20_29 vssd vssd vccd vccd sky130_fd_sc_hd__fill_2
X_166_ net48 net47 net44 net55 vssd vssd vccd vccd _089_ sky130_fd_sc_hd__and4bb_2
XFILLER_10_51 vssd vssd vccd vccd sky130_fd_sc_hd__decap_3
XFILLER_28_103 vssd vssd vccd vccd sky130_fd_sc_hd__decap_3
XFILLER_28_147 vssd vssd vccd vccd sky130_fd_sc_hd__decap_3
XFILLER_28_169 vssd vssd vccd vccd sky130_fd_sc_hd__decap_3
XFILLER_19_169 vssd vssd vccd vccd sky130_fd_sc_hd__decap_3
X_218_ net25 regs\[2\]\[0\] _128_ vssd vssd vccd vccd _016_ sky130_fd_sc_hd__mux2_1
X_149_ regs\[7\]\[0\] _070_ net19 regs\[1\]\[0\] vssd vssd vccd vccd _072_ sky130_fd_sc_hd__a22o_1
XFILLER_15_18 vssd vssd vccd vccd sky130_fd_sc_hd__fill_1
XFILLER_21_72 vssd vssd vccd vccd sky130_fd_sc_hd__fill_2
XFILLER_21_94 vssd vssd vccd vccd sky130_fd_sc_hd__decap_3
XFILLER_26_39 vssd vssd vccd vccd sky130_fd_sc_hd__decap_3
XTAP_TAPCELL_ROW_17_112 vssd vccd sky130_fd_sc_hd__tapvpwrvgnd_1
XFILLER_12_153 vssd vssd vccd vccd sky130_fd_sc_hd__decap_3
XFILLER_21_131 vssd vssd vccd vccd sky130_fd_sc_hd__decap_3
XTAP_TAPCELL_ROW_14_104 vssd vccd sky130_fd_sc_hd__tapvpwrvgnd_1
XFILLER_8_113 vssd vssd vccd vccd sky130_fd_sc_hd__decap_3
XFILLER_8_135 vssd vssd vccd vccd sky130_fd_sc_hd__decap_3
XPHY_EDGE_ROW_19_Left_48 vssd vssd vccd vccd sky130_fd_sc_hd__decap_3
XFILLER_5_127 vssd vssd vccd vccd sky130_fd_sc_hd__decap_3
XFILLER_27_60 vssd vssd vccd vccd sky130_fd_sc_hd__decap_3
XFILLER_23_18 vssd vssd vccd vccd sky130_fd_sc_hd__fill_1
XFILLER_1_141 vssd vssd vccd vccd sky130_fd_sc_hd__decap_3
X_320_ net41 _038_ net32 vssd vssd vccd vccd regs\[7\]\[2\] sky130_fd_sc_hd__dfrtp_1
Xfanout30 net34 vssd vssd vccd vccd net30 sky130_fd_sc_hd__clkbuf_4
Xfanout41 net43 vssd vssd vccd vccd net41 sky130_fd_sc_hd__clkbuf_2
Xfanout52 net11 vssd vssd vccd vccd net52 sky130_fd_sc_hd__clkbuf_4
X_251_ net53 regs\[8\]\[3\] _134_ vssd vssd vccd vccd _043_ sky130_fd_sc_hd__mux2_1
X_182_ regs\[10\]\[1\] _086_ _099_ _101_ net16 vssd vssd vccd vccd _104_ sky130_fd_sc_hd__a2111o_1
XFILLER_18_18 vssd vssd vccd vccd sky130_fd_sc_hd__decap_3
XFILLER_18_29 vssd vssd vccd vccd sky130_fd_sc_hd__decap_3
XFILLER_1_21 vssd vssd vccd vccd sky130_fd_sc_hd__decap_3
XFILLER_24_94 vssd vssd vccd vccd sky130_fd_sc_hd__fill_1
XFILLER_27_6 vssd vssd vccd vccd sky130_fd_sc_hd__decap_3
X_303_ net39 _021_ net30 vssd vssd vccd vccd regs\[3\]\[1\] sky130_fd_sc_hd__dfrtp_1
X_234_ net22 regs\[5\]\[1\] _131_ vssd vssd vccd vccd _029_ sky130_fd_sc_hd__mux2_1
X_165_ net49 net56 net45 net46 vssd vssd vccd vccd _088_ sky130_fd_sc_hd__and4b_2
XFILLER_28_126 vssd vssd vccd vccd sky130_fd_sc_hd__decap_3
XFILLER_28_159 vssd vssd vccd vccd sky130_fd_sc_hd__decap_3
XPHY_EDGE_ROW_7_Left_36 vssd vssd vccd vccd sky130_fd_sc_hd__decap_3
XFILLER_10_41 vssd vssd vccd vccd sky130_fd_sc_hd__decap_3
XFILLER_19_148 vssd vssd vccd vccd sky130_fd_sc_hd__decap_3
X_217_ net50 net18 vssd vssd vccd vccd _128_ sky130_fd_sc_hd__nand2_2
X_148_ net48 net44 net46 net55 vssd vssd vccd vccd _071_ sky130_fd_sc_hd__nor4b_1
XFILLER_18_170 vssd vssd vccd vccd sky130_fd_sc_hd__fill_2
XFILLER_25_107 vssd vssd vccd vccd sky130_fd_sc_hd__decap_3
XFILLER_25_3 vssd vssd vccd vccd sky130_fd_sc_hd__decap_3
XFILLER_16_107 vssd vssd vccd vccd sky130_fd_sc_hd__decap_3
XTAP_TAPCELL_ROW_17_113 vssd vccd sky130_fd_sc_hd__tapvpwrvgnd_1
XFILLER_26_18 vssd vssd vccd vccd sky130_fd_sc_hd__decap_3
XPHY_EDGE_ROW_5_Right_5 vssd vssd vccd vccd sky130_fd_sc_hd__decap_3
XFILLER_12_132 vssd vssd vccd vccd sky130_fd_sc_hd__decap_3
XFILLER_12_165 vssd vssd vccd vccd sky130_fd_sc_hd__decap_3
XFILLER_16_40 vssd vssd vccd vccd sky130_fd_sc_hd__decap_3
XFILLER_8_147 vssd vssd vccd vccd sky130_fd_sc_hd__fill_2
XTAP_TAPCELL_ROW_14_105 vssd vccd sky130_fd_sc_hd__tapvpwrvgnd_1
XPHY_EDGE_ROW_20_Left_49 vssd vssd vccd vccd sky130_fd_sc_hd__decap_3
XFILLER_13_30 vssd vssd vccd vccd sky130_fd_sc_hd__fill_2
XFILLER_13_52 vssd vssd vccd vccd sky130_fd_sc_hd__decap_3
Xfanout20 net9 vssd vssd vccd vccd net20 sky130_fd_sc_hd__buf_2
Xfanout31 net34 vssd vssd vccd vccd net31 sky130_fd_sc_hd__clkbuf_2
Xfanout42 net43 vssd vssd vccd vccd net42 sky130_fd_sc_hd__clkbuf_2
Xfanout53 net10 vssd vssd vccd vccd net53 sky130_fd_sc_hd__buf_2
X_250_ net21 regs\[8\]\[2\] _134_ vssd vssd vccd vccd _042_ sky130_fd_sc_hd__mux2_1
X_181_ regs\[4\]\[1\] _074_ _082_ regs\[6\]\[1\] _098_ vssd vssd vccd vccd _103_ sky130_fd_sc_hd__a221o_1
XFILLER_1_153 vssd vssd vccd vccd sky130_fd_sc_hd__decap_3
XFILLER_1_33 vssd vssd vccd vccd sky130_fd_sc_hd__decap_3
XFILLER_1_66 vssd vssd vccd vccd sky130_fd_sc_hd__decap_3
XFILLER_1_88 vssd vssd vccd vccd sky130_fd_sc_hd__decap_3
X_302_ net39 _020_ net30 vssd vssd vccd vccd regs\[3\]\[0\] sky130_fd_sc_hd__dfrtp_1
X_233_ net24 regs\[5\]\[0\] _131_ vssd vssd vccd vccd _028_ sky130_fd_sc_hd__mux2_1
X_164_ regs\[12\]\[0\] _085_ _086_ regs\[10\]\[0\] vssd vssd vccd vccd _087_ sky130_fd_sc_hd__a22o_1
XFILLER_28_138 vssd vssd vccd vccd sky130_fd_sc_hd__fill_2
XPHY_EDGE_ROW_23_Left_52 vssd vssd vccd vccd sky130_fd_sc_hd__decap_3
XFILLER_27_160 vssd vssd vccd vccd sky130_fd_sc_hd__decap_3
XFILLER_18_3 vssd vssd vccd vccd sky130_fd_sc_hd__decap_3
XFILLER_25_119 vssd vssd vccd vccd sky130_fd_sc_hd__decap_3
X_216_ net53 regs\[1\]\[3\] _127_ vssd vssd vccd vccd _015_ sky130_fd_sc_hd__mux2_1
X_147_ net44 net46 net48 net55 vssd vssd vccd vccd _070_ sky130_fd_sc_hd__and4b_2
XFILLER_21_52 vssd vssd vccd vccd sky130_fd_sc_hd__decap_3
XFILLER_24_141 vssd vssd vccd vccd sky130_fd_sc_hd__decap_3
XFILLER_7_54 vssd vssd vccd vccd sky130_fd_sc_hd__fill_2
XTAP_TAPCELL_ROW_17_114 vssd vccd sky130_fd_sc_hd__tapvpwrvgnd_1
XFILLER_21_100 vssd vssd vccd vccd sky130_fd_sc_hd__decap_3
XFILLER_21_122 vssd vssd vccd vccd sky130_fd_sc_hd__decap_3
XFILLER_16_63 vssd vssd vccd vccd sky130_fd_sc_hd__fill_2
XFILLER_8_104 vssd vssd vccd vccd sky130_fd_sc_hd__decap_3
XPHY_EDGE_ROW_11_Right_11 vssd vssd vccd vccd sky130_fd_sc_hd__decap_3
XPHY_EDGE_ROW_20_Right_20 vssd vssd vccd vccd sky130_fd_sc_hd__decap_3
XFILLER_27_51 vssd vssd vccd vccd sky130_fd_sc_hd__decap_3
XFILLER_4_162 vssd vssd vccd vccd sky130_fd_sc_hd__decap_3
XFILLER_4_33 vssd vssd vccd vccd sky130_fd_sc_hd__decap_3
XFILLER_4_44 vssd vssd vccd vccd sky130_fd_sc_hd__decap_3
XFILLER_4_66 vssd vssd vccd vccd sky130_fd_sc_hd__decap_3
XFILLER_4_88 vssd vssd vccd vccd sky130_fd_sc_hd__fill_1
XFILLER_13_86 vssd vssd vccd vccd sky130_fd_sc_hd__fill_1
Xfanout21 net9 vssd vssd vccd vccd net21 sky130_fd_sc_hd__dlymetal6s2s_1
Xfanout32 net34 vssd vssd vccd vccd net32 sky130_fd_sc_hd__clkbuf_4
Xfanout43 net5 vssd vssd vccd vccd net43 sky130_fd_sc_hd__buf_2
Xfanout54 net10 vssd vssd vccd vccd net54 sky130_fd_sc_hd__dlymetal6s2s_1
X_180_ regs\[7\]\[1\] _070_ _084_ regs\[8\]\[1\] _100_ vssd vssd vccd vccd _102_ sky130_fd_sc_hd__a221o_1
XFILLER_1_132 vssd vssd vccd vccd sky130_fd_sc_hd__decap_3
XFILLER_1_165 vssd vssd vccd vccd sky130_fd_sc_hd__decap_3
XFILLER_1_9 vssd vssd vccd vccd sky130_fd_sc_hd__decap_3
XFILLER_1_12 vssd vssd vccd vccd sky130_fd_sc_hd__decap_3
X_301_ net40 _019_ net31 vssd vssd vccd vccd regs\[2\]\[3\] sky130_fd_sc_hd__dfrtp_1
X_232_ net50 _077_ vssd vssd vccd vccd _131_ sky130_fd_sc_hd__nand2_2
X_163_ net56 net47 net45 net49 vssd vssd vccd vccd _086_ sky130_fd_sc_hd__and4bb_2
XFILLER_1_78 vssd vssd vccd vccd sky130_fd_sc_hd__fill_1
XFILLER_28_106 vssd vssd vccd vccd sky130_fd_sc_hd__decap_3
XFILLER_10_32 vssd vssd vccd vccd sky130_fd_sc_hd__decap_3
XFILLER_10_54 vssd vssd vccd vccd sky130_fd_sc_hd__decap_3
X_215_ net20 regs\[1\]\[2\] _127_ vssd vssd vccd vccd _014_ sky130_fd_sc_hd__mux2_1
X_146_ net53 regs\[15\]\[3\] _069_ vssd vssd vccd vccd _003_ sky130_fd_sc_hd__mux2_1
XFILLER_24_131 vssd vssd vccd vccd sky130_fd_sc_hd__decap_3
XFILLER_15_131 vssd vssd vccd vccd sky130_fd_sc_hd__decap_3
XFILLER_21_97 vssd vssd vccd vccd sky130_fd_sc_hd__decap_3
XFILLER_7_66 vssd vssd vccd vccd sky130_fd_sc_hd__decap_3
XFILLER_21_134 vssd vssd vccd vccd sky130_fd_sc_hd__decap_3
XFILLER_12_112 vssd vssd vccd vccd sky130_fd_sc_hd__decap_3
XFILLER_8_116 vssd vssd vccd vccd sky130_fd_sc_hd__decap_3
XFILLER_8_138 vssd vssd vccd vccd sky130_fd_sc_hd__fill_2
XFILLER_27_30 vssd vssd vccd vccd sky130_fd_sc_hd__decap_3
XFILLER_5_108 vssd vssd vccd vccd sky130_fd_sc_hd__decap_3
XFILLER_4_141 vssd vssd vccd vccd sky130_fd_sc_hd__decap_3
Xfanout22 net8 vssd vssd vccd vccd net22 sky130_fd_sc_hd__clkbuf_2
Xfanout33 net34 vssd vssd vccd vccd net33 sky130_fd_sc_hd__buf_2
Xfanout44 net4 vssd vssd vccd vccd net44 sky130_fd_sc_hd__clkbuf_2
Xfanout55 net1 vssd vssd vccd vccd net55 sky130_fd_sc_hd__clkbuf_2
XFILLER_1_144 vssd vssd vccd vccd sky130_fd_sc_hd__decap_3
XFILLER_8_3 vssd vssd vccd vccd sky130_fd_sc_hd__decap_3
XTAP_TAPCELL_ROW_9_88 vssd vccd sky130_fd_sc_hd__tapvpwrvgnd_1
XFILLER_24_64 vssd vssd vccd vccd sky130_fd_sc_hd__fill_1
X_300_ net39 _018_ net30 vssd vssd vccd vccd regs\[2\]\[2\] sky130_fd_sc_hd__dfrtp_1
X_231_ net54 regs\[4\]\[3\] _130_ vssd vssd vccd vccd _027_ sky130_fd_sc_hd__mux2_1
X_162_ net45 net46 _073_ vssd vssd vccd vccd _085_ sky130_fd_sc_hd__and3_2
XFILLER_1_24 vssd vssd vccd vccd sky130_fd_sc_hd__decap_3
XFILLER_27_9 vssd vssd vccd vccd sky130_fd_sc_hd__decap_3
XFILLER_10_99 vssd vssd vccd vccd sky130_fd_sc_hd__decap_3
XFILLER_19_107 vssd vssd vccd vccd sky130_fd_sc_hd__decap_3
XFILLER_28_129 vssd vssd vccd vccd sky130_fd_sc_hd__decap_3
Xinput1 addr[0] vssd vssd vccd vccd net1 sky130_fd_sc_hd__buf_1
XFILLER_19_97 vssd vssd vccd vccd sky130_fd_sc_hd__fill_2
XFILLER_25_6 vssd vssd vccd vccd sky130_fd_sc_hd__decap_3
XFILLER_27_151 vssd vssd vccd vccd sky130_fd_sc_hd__decap_3
X_214_ net23 regs\[1\]\[1\] _127_ vssd vssd vccd vccd _013_ sky130_fd_sc_hd__mux2_1
X_145_ net20 regs\[15\]\[2\] _069_ vssd vssd vccd vccd _002_ sky130_fd_sc_hd__mux2_1
XFILLER_21_32 vssd vssd vccd vccd sky130_fd_sc_hd__decap_3
XFILLER_21_146 vssd vssd vccd vccd sky130_fd_sc_hd__fill_2
XFILLER_23_3 vssd vssd vccd vccd sky130_fd_sc_hd__decap_3
XFILLER_7_12 vssd vssd vccd vccd sky130_fd_sc_hd__decap_3
XFILLER_12_135 vssd vssd vccd vccd sky130_fd_sc_hd__decap_3
XFILLER_12_168 vssd vssd vccd vccd sky130_fd_sc_hd__decap_3
XFILLER_16_21 vssd vssd vccd vccd sky130_fd_sc_hd__decap_3
XFILLER_16_76 vssd vssd vccd vccd sky130_fd_sc_hd__decap_3
XFILLER_16_98 vssd vssd vccd vccd sky130_fd_sc_hd__decap_3
XPHY_EDGE_ROW_9_Right_9 vssd vssd vccd vccd sky130_fd_sc_hd__decap_3
XFILLER_27_42 vssd vssd vccd vccd sky130_fd_sc_hd__decap_3
XFILLER_13_55 vssd vssd vccd vccd sky130_fd_sc_hd__fill_1
XFILLER_1_156 vssd vssd vccd vccd sky130_fd_sc_hd__decap_3
Xfanout23 net8 vssd vssd vccd vccd net23 sky130_fd_sc_hd__buf_1
Xfanout34 net6 vssd vssd vccd vccd net34 sky130_fd_sc_hd__buf_2
Xfanout45 net4 vssd vssd vccd vccd net45 sky130_fd_sc_hd__buf_1
Xfanout56 net1 vssd vssd vccd vccd net56 sky130_fd_sc_hd__buf_1
XTAP_TAPCELL_ROW_9_89 vssd vccd sky130_fd_sc_hd__tapvpwrvgnd_1
XTAP_TAPCELL_ROW_0_58 vssd vccd sky130_fd_sc_hd__tapvpwrvgnd_1
XFILLER_24_21 vssd vssd vccd vccd sky130_fd_sc_hd__decap_3
XFILLER_24_32 vssd vssd vccd vccd sky130_fd_sc_hd__fill_2
XFILLER_24_43 vssd vssd vccd vccd sky130_fd_sc_hd__decap_3
XFILLER_24_76 vssd vssd vccd vccd sky130_fd_sc_hd__decap_3
X_230_ net21 regs\[4\]\[2\] _130_ vssd vssd vccd vccd _026_ sky130_fd_sc_hd__mux2_1
X_161_ net46 _073_ net45 vssd vssd vccd vccd _084_ sky130_fd_sc_hd__and3b_2
XFILLER_1_69 vssd vssd vccd vccd sky130_fd_sc_hd__decap_3
XFILLER_10_12 vssd vssd vccd vccd sky130_fd_sc_hd__decap_3
XFILLER_28_119 vssd vssd vccd vccd sky130_fd_sc_hd__decap_3
Xinput2 addr[1] vssd vssd vccd vccd net2 sky130_fd_sc_hd__buf_1
XFILLER_10_89 vssd vssd vccd vccd sky130_fd_sc_hd__fill_1
XFILLER_19_87 vssd vssd vccd vccd sky130_fd_sc_hd__fill_1
XFILLER_27_163 vssd vssd vccd vccd sky130_fd_sc_hd__decap_3
X_213_ net25 regs\[1\]\[0\] _127_ vssd vssd vccd vccd _012_ sky130_fd_sc_hd__mux2_1
X_144_ net22 regs\[15\]\[1\] _069_ vssd vssd vccd vccd _001_ sky130_fd_sc_hd__mux2_1
XTAP_TAPCELL_ROW_6_79 vssd vccd sky130_fd_sc_hd__tapvpwrvgnd_1
XPHY_EDGE_ROW_27_Left_56 vssd vssd vccd vccd sky130_fd_sc_hd__decap_3
XFILLER_18_6 vssd vssd vccd vccd sky130_fd_sc_hd__decap_3
XFILLER_21_55 vssd vssd vccd vccd sky130_fd_sc_hd__fill_1
XFILLER_21_66 vssd vssd vccd vccd sky130_fd_sc_hd__decap_3
XFILLER_24_122 vssd vssd vccd vccd sky130_fd_sc_hd__decap_3
XFILLER_24_144 vssd vssd vccd vccd sky130_fd_sc_hd__decap_3
XFILLER_24_166 vssd vssd vccd vccd sky130_fd_sc_hd__fill_2
XTAP_TAPCELL_ROW_26_139 vssd vccd sky130_fd_sc_hd__tapvpwrvgnd_1
XFILLER_15_122 vssd vssd vccd vccd sky130_fd_sc_hd__decap_3
XFILLER_21_103 vssd vssd vccd vccd sky130_fd_sc_hd__fill_1
XFILLER_12_103 vssd vssd vccd vccd sky130_fd_sc_hd__decap_3
XFILLER_16_55 vssd vssd vccd vccd sky130_fd_sc_hd__decap_3
XFILLER_21_125 vssd vssd vccd vccd sky130_fd_sc_hd__decap_3
XFILLER_21_169 vssd vssd vccd vccd sky130_fd_sc_hd__decap_3
XFILLER_8_107 vssd vssd vccd vccd sky130_fd_sc_hd__decap_3
XFILLER_7_140 vssd vssd vccd vccd sky130_fd_sc_hd__fill_1
XPHY_EDGE_ROW_14_Left_43 vssd vssd vccd vccd sky130_fd_sc_hd__decap_3
XFILLER_27_21 vssd vssd vccd vccd sky130_fd_sc_hd__decap_3
XFILLER_27_54 vssd vssd vccd vccd sky130_fd_sc_hd__fill_2
XFILLER_4_132 vssd vssd vccd vccd sky130_fd_sc_hd__decap_3
XFILLER_4_165 vssd vssd vccd vccd sky130_fd_sc_hd__decap_3
XFILLER_4_36 vssd vssd vccd vccd sky130_fd_sc_hd__decap_3
XFILLER_4_47 vssd vssd vccd vccd sky130_fd_sc_hd__decap_3
XFILLER_4_58 vssd vssd vccd vccd sky130_fd_sc_hd__decap_3
XFILLER_4_69 vssd vssd vccd vccd sky130_fd_sc_hd__decap_3
XFILLER_1_113 vssd vssd vccd vccd sky130_fd_sc_hd__decap_3
XFILLER_1_135 vssd vssd vccd vccd sky130_fd_sc_hd__decap_3
Xfanout24 net7 vssd vssd vccd vccd net24 sky130_fd_sc_hd__buf_2
Xfanout35 net43 vssd vssd vccd vccd net35 sky130_fd_sc_hd__clkbuf_2
Xfanout46 net47 vssd vssd vccd vccd net46 sky130_fd_sc_hd__clkbuf_2
XTAP_TAPCELL_ROW_0_59 vssd vccd sky130_fd_sc_hd__tapvpwrvgnd_1
XFILLER_5_90 vssd vssd vccd vccd sky130_fd_sc_hd__decap_3
XFILLER_1_15 vssd vssd vccd vccd sky130_fd_sc_hd__decap_3
X_160_ regs\[3\]\[0\] _081_ _082_ regs\[6\]\[0\] _080_ vssd vssd vccd vccd _083_ sky130_fd_sc_hd__a221o_1
XFILLER_28_109 vssd vssd vccd vccd sky130_fd_sc_hd__decap_3
XPHY_EDGE_ROW_18_Right_18 vssd vssd vccd vccd sky130_fd_sc_hd__decap_3
Xinput3 addr[2] vssd vssd vccd vccd net3 sky130_fd_sc_hd__clkbuf_1
X_289_ net42 _007_ net33 vssd vssd vccd vccd net15 sky130_fd_sc_hd__dfrtp_1
XPHY_EDGE_ROW_27_Right_27 vssd vssd vccd vccd sky130_fd_sc_hd__decap_3
XFILLER_10_35 vssd vssd vccd vccd sky130_fd_sc_hd__decap_3
XFILLER_10_57 vssd vssd vccd vccd sky130_fd_sc_hd__fill_2
XFILLER_19_66 vssd vssd vccd vccd sky130_fd_sc_hd__fill_2
XFILLER_19_77 vssd vssd vccd vccd sky130_fd_sc_hd__decap_3
XFILLER_27_142 vssd vssd vccd vccd sky130_fd_sc_hd__decap_3
X_212_ net51 net19 vssd vssd vccd vccd _127_ sky130_fd_sc_hd__nand2_2
X_143_ net24 regs\[15\]\[0\] _069_ vssd vssd vccd vccd _000_ sky130_fd_sc_hd__mux2_1
XPHY_EDGE_ROW_2_Left_31 vssd vssd vccd vccd sky130_fd_sc_hd__decap_3
XFILLER_18_131 vssd vssd vccd vccd sky130_fd_sc_hd__decap_3
XFILLER_24_134 vssd vssd vccd vccd sky130_fd_sc_hd__decap_3
XFILLER_15_134 vssd vssd vccd vccd sky130_fd_sc_hd__fill_2
XFILLER_15_167 vssd vssd vccd vccd sky130_fd_sc_hd__fill_1
XFILLER_7_69 vssd vssd vccd vccd sky130_fd_sc_hd__fill_1
XFILLER_16_12 vssd vssd vccd vccd sky130_fd_sc_hd__decap_3
XFILLER_21_137 vssd vssd vccd vccd sky130_fd_sc_hd__fill_2
XFILLER_12_115 vssd vssd vccd vccd sky130_fd_sc_hd__fill_2
XFILLER_12_126 vssd vssd vccd vccd sky130_fd_sc_hd__decap_3
XFILLER_8_119 vssd vssd vccd vccd sky130_fd_sc_hd__decap_3
XPHY_EDGE_ROW_0_Right_0 vssd vssd vccd vccd sky130_fd_sc_hd__decap_3
XFILLER_27_33 vssd vssd vccd vccd sky130_fd_sc_hd__decap_3
XFILLER_4_111 vssd vssd vccd vccd sky130_fd_sc_hd__fill_1
XFILLER_4_144 vssd vssd vccd vccd sky130_fd_sc_hd__fill_1
XFILLER_1_147 vssd vssd vccd vccd sky130_fd_sc_hd__decap_3
XFILLER_8_6 vssd vssd vccd vccd sky130_fd_sc_hd__decap_3
Xfanout25 net7 vssd vssd vccd vccd net25 sky130_fd_sc_hd__dlymetal6s2s_1
Xfanout36 net43 vssd vssd vccd vccd net36 sky130_fd_sc_hd__clkbuf_2
Xfanout47 net3 vssd vssd vccd vccd net47 sky130_fd_sc_hd__clkbuf_2
XFILLER_1_169 vssd vssd vccd vccd sky130_fd_sc_hd__decap_3
XFILLER_1_27 vssd vssd vccd vccd sky130_fd_sc_hd__decap_3
XFILLER_24_12 vssd vssd vccd vccd sky130_fd_sc_hd__decap_3
XFILLER_6_3 vssd vssd vccd vccd sky130_fd_sc_hd__fill_1
Xinput4 addr[3] vssd vssd vccd vccd net4 sky130_fd_sc_hd__buf_1
X_288_ net42 _006_ net33 vssd vssd vccd vccd net14 sky130_fd_sc_hd__dfrtp_1
XFILLER_19_12 vssd vssd vccd vccd sky130_fd_sc_hd__decap_3
XFILLER_27_154 vssd vssd vccd vccd sky130_fd_sc_hd__decap_3
X_211_ net53 regs\[0\]\[3\] _126_ vssd vssd vccd vccd _011_ sky130_fd_sc_hd__mux2_1
X_142_ net52 _068_ vssd vssd vccd vccd _069_ sky130_fd_sc_hd__nand2_1
XFILLER_25_9 vssd vssd vccd vccd sky130_fd_sc_hd__decap_3
XFILLER_21_35 vssd vssd vccd vccd sky130_fd_sc_hd__decap_3
XFILLER_21_46 vssd vssd vccd vccd sky130_fd_sc_hd__decap_3
XFILLER_24_102 vssd vssd vccd vccd sky130_fd_sc_hd__decap_3
XFILLER_11_90 vssd vssd vccd vccd sky130_fd_sc_hd__decap_3
XFILLER_15_113 vssd vssd vccd vccd sky130_fd_sc_hd__decap_3
XFILLER_7_15 vssd vssd vccd vccd sky130_fd_sc_hd__decap_3
XFILLER_7_48 vssd vssd vccd vccd sky130_fd_sc_hd__decap_3
XFILLER_23_6 vssd vssd vccd vccd sky130_fd_sc_hd__decap_3
XFILLER_12_138 vssd vssd vccd vccd sky130_fd_sc_hd__fill_2
XFILLER_16_24 vssd vssd vccd vccd sky130_fd_sc_hd__decap_3
XFILLER_16_79 vssd vssd vccd vccd sky130_fd_sc_hd__decap_3
XFILLER_21_3 vssd vssd vccd vccd sky130_fd_sc_hd__decap_3
XTAP_TAPCELL_ROW_13_100 vssd vccd sky130_fd_sc_hd__tapvpwrvgnd_1
XFILLER_27_12 vssd vssd vccd vccd sky130_fd_sc_hd__decap_3
XFILLER_27_45 vssd vssd vccd vccd sky130_fd_sc_hd__decap_3
XFILLER_8_80 vssd vssd vccd vccd sky130_fd_sc_hd__decap_3
XFILLER_4_27 vssd vssd vccd vccd sky130_fd_sc_hd__fill_1
Xfanout26 net34 vssd vssd vccd vccd net26 sky130_fd_sc_hd__clkbuf_4
Xfanout37 net43 vssd vssd vccd vccd net37 sky130_fd_sc_hd__clkbuf_2
Xfanout48 net2 vssd vssd vccd vccd net48 sky130_fd_sc_hd__clkbuf_2
XFILLER_1_159 vssd vssd vccd vccd sky130_fd_sc_hd__decap_3
XFILLER_24_24 vssd vssd vccd vccd sky130_fd_sc_hd__decap_3
XFILLER_24_46 vssd vssd vccd vccd sky130_fd_sc_hd__decap_3
XFILLER_24_79 vssd vssd vccd vccd sky130_fd_sc_hd__decap_3
Xinput5 clk vssd vssd vccd vccd net5 sky130_fd_sc_hd__clkbuf_1
X_287_ net41 _005_ net32 vssd vssd vccd vccd net13 sky130_fd_sc_hd__dfrtp_1
XFILLER_10_15 vssd vssd vccd vccd sky130_fd_sc_hd__fill_2
XFILLER_10_26 vssd vssd vccd vccd sky130_fd_sc_hd__fill_2
XFILLER_27_133 vssd vssd vccd vccd sky130_fd_sc_hd__decap_3
XFILLER_27_166 vssd vssd vccd vccd sky130_fd_sc_hd__fill_2
XFILLER_18_111 vssd vssd vccd vccd sky130_fd_sc_hd__decap_3
XFILLER_18_9 vssd vssd vccd vccd sky130_fd_sc_hd__decap_3
X_210_ net20 regs\[0\]\[2\] _126_ vssd vssd vccd vccd _010_ sky130_fd_sc_hd__mux2_1
X_141_ net48 net55 net44 net46 vssd vssd vccd vccd _068_ sky130_fd_sc_hd__and4_1
XTAP_TAPCELL_ROW_28_150 vssd vccd sky130_fd_sc_hd__tapvpwrvgnd_1
XFILLER_24_114 vssd vssd vccd vccd sky130_fd_sc_hd__fill_1
XFILLER_24_125 vssd vssd vccd vccd sky130_fd_sc_hd__decap_3
XFILLER_24_147 vssd vssd vccd vccd sky130_fd_sc_hd__fill_2
X_339_ net38 _057_ net29 vssd vssd vccd vccd regs\[12\]\[1\] sky130_fd_sc_hd__dfrtp_1
XFILLER_15_125 vssd vssd vccd vccd sky130_fd_sc_hd__decap_3
XFILLER_15_169 vssd vssd vccd vccd sky130_fd_sc_hd__decap_3
XFILLER_21_69 vssd vssd vccd vccd sky130_fd_sc_hd__decap_3
XFILLER_16_6 vssd vssd vccd vccd sky130_fd_sc_hd__decap_3
XFILLER_21_128 vssd vssd vccd vccd sky130_fd_sc_hd__decap_3
XFILLER_12_106 vssd vssd vccd vccd sky130_fd_sc_hd__decap_3
XFILLER_16_58 vssd vssd vccd vccd sky130_fd_sc_hd__fill_2
XFILLER_20_150 vssd vssd vccd vccd sky130_fd_sc_hd__decap_3
XFILLER_11_150 vssd vssd vccd vccd sky130_fd_sc_hd__fill_2
XFILLER_7_110 vssd vssd vccd vccd sky130_fd_sc_hd__fill_2
XTAP_TAPCELL_ROW_13_101 vssd vccd sky130_fd_sc_hd__tapvpwrvgnd_1
XFILLER_27_24 vssd vssd vccd vccd sky130_fd_sc_hd__decap_3
XFILLER_27_57 vssd vssd vccd vccd sky130_fd_sc_hd__decap_3
XFILLER_4_135 vssd vssd vccd vccd sky130_fd_sc_hd__decap_3
XFILLER_4_168 vssd vssd vccd vccd sky130_fd_sc_hd__fill_1
XPHY_EDGE_ROW_18_Left_47 vssd vssd vccd vccd sky130_fd_sc_hd__decap_3
Xfanout27 net34 vssd vssd vccd vccd net27 sky130_fd_sc_hd__buf_2
Xfanout38 net43 vssd vssd vccd vccd net38 sky130_fd_sc_hd__dlymetal6s2s_1
Xfanout49 net2 vssd vssd vccd vccd net49 sky130_fd_sc_hd__buf_1
XFILLER_1_116 vssd vssd vccd vccd sky130_fd_sc_hd__decap_3
XFILLER_1_138 vssd vssd vccd vccd sky130_fd_sc_hd__decap_3
XFILLER_1_18 vssd vssd vccd vccd sky130_fd_sc_hd__decap_3
X_286_ net41 _004_ net32 vssd vssd vccd vccd net12 sky130_fd_sc_hd__dfrtp_1
XFILLER_10_38 vssd vssd vccd vccd sky130_fd_sc_hd__decap_3
Xinput6 nrst vssd vssd vccd vccd net6 sky130_fd_sc_hd__clkbuf_1
XFILLER_18_134 vssd vssd vccd vccd sky130_fd_sc_hd__decap_3
XFILLER_27_145 vssd vssd vccd vccd sky130_fd_sc_hd__decap_3
XPHY_EDGE_ROW_14_Right_14 vssd vssd vccd vccd sky130_fd_sc_hd__decap_3
XPHY_EDGE_ROW_23_Right_23 vssd vssd vccd vccd sky130_fd_sc_hd__decap_3
XFILLER_24_137 vssd vssd vccd vccd sky130_fd_sc_hd__decap_3
X_338_ net37 _056_ net28 vssd vssd vccd vccd regs\[12\]\[0\] sky130_fd_sc_hd__dfrtp_1
X_269_ net23 regs\[12\]\[1\] _138_ vssd vssd vccd vccd _057_ sky130_fd_sc_hd__mux2_1
XPHY_EDGE_ROW_6_Left_35 vssd vssd vccd vccd sky130_fd_sc_hd__decap_3
XFILLER_11_81 vssd vssd vccd vccd sky130_fd_sc_hd__decap_3
XTAP_TAPCELL_ROW_7_82 vssd vccd sky130_fd_sc_hd__tapvpwrvgnd_1
XTAP_TAPCELL_ROW_16_110 vssd vccd sky130_fd_sc_hd__tapvpwrvgnd_1
XFILLER_12_129 vssd vssd vccd vccd sky130_fd_sc_hd__decap_3
XFILLER_16_15 vssd vssd vccd vccd sky130_fd_sc_hd__decap_3
XFILLER_11_162 vssd vssd vccd vccd sky130_fd_sc_hd__decap_3
XTAP_TAPCELL_ROW_13_102 vssd vccd sky130_fd_sc_hd__tapvpwrvgnd_1
XFILLER_8_71 vssd vssd vccd vccd sky130_fd_sc_hd__decap_3
XPHY_EDGE_ROW_4_Right_4 vssd vssd vccd vccd sky130_fd_sc_hd__decap_3
XFILLER_27_36 vssd vssd vccd vccd sky130_fd_sc_hd__decap_3
XFILLER_8_9 vssd vssd vccd vccd sky130_fd_sc_hd__decap_3
Xfanout28 net34 vssd vssd vccd vccd net28 sky130_fd_sc_hd__clkbuf_4
Xfanout39 net43 vssd vssd vccd vccd net39 sky130_fd_sc_hd__clkbuf_2
XFILLER_0_150 vssd vssd vccd vccd sky130_fd_sc_hd__decap_3
XFILLER_24_15 vssd vssd vccd vccd sky130_fd_sc_hd__decap_3
X_285_ net37 _003_ net28 vssd vssd vccd vccd regs\[15\]\[3\] sky130_fd_sc_hd__dfrtp_1
Xinput7 wdata[0] vssd vssd vccd vccd net7 sky130_fd_sc_hd__buf_1
XFILLER_19_15 vssd vssd vccd vccd sky130_fd_sc_hd__fill_1
XFILLER_27_157 vssd vssd vccd vccd sky130_fd_sc_hd__decap_3
XFILLER_4_3 vssd vssd vccd vccd sky130_fd_sc_hd__decap_3
XFILLER_18_102 vssd vssd vccd vccd sky130_fd_sc_hd__decap_3
XPHY_EDGE_ROW_22_Left_51 vssd vssd vccd vccd sky130_fd_sc_hd__decap_3
X_337_ net37 _055_ net28 vssd vssd vccd vccd regs\[11\]\[3\] sky130_fd_sc_hd__dfrtp_1
X_268_ net24 regs\[12\]\[0\] _138_ vssd vssd vccd vccd _056_ sky130_fd_sc_hd__mux2_1
X_199_ regs\[3\]\[3\] _081_ _088_ regs\[13\]\[3\] net17 vssd vssd vccd vccd _119_
+ sky130_fd_sc_hd__a221o_1
XFILLER_15_116 vssd vssd vccd vccd sky130_fd_sc_hd__decap_3
XFILLER_21_38 vssd vssd vccd vccd sky130_fd_sc_hd__decap_3
XFILLER_21_49 vssd vssd vccd vccd sky130_fd_sc_hd__decap_3
XFILLER_24_105 vssd vssd vccd vccd sky130_fd_sc_hd__fill_1
XFILLER_11_60 vssd vssd vccd vccd sky130_fd_sc_hd__decap_3
XFILLER_11_93 vssd vssd vccd vccd sky130_fd_sc_hd__decap_3
XFILLER_15_149 vssd vssd vccd vccd sky130_fd_sc_hd__decap_3
XFILLER_23_9 vssd vssd vccd vccd sky130_fd_sc_hd__decap_3
XFILLER_7_18 vssd vssd vccd vccd sky130_fd_sc_hd__fill_1
XTAP_TAPCELL_ROW_7_83 vssd vccd sky130_fd_sc_hd__tapvpwrvgnd_1
XTAP_TAPCELL_ROW_16_111 vssd vccd sky130_fd_sc_hd__tapvpwrvgnd_1
XFILLER_16_27 vssd vssd vccd vccd sky130_fd_sc_hd__fill_1
Xinput10 wdata[3] vssd vssd vccd vccd net10 sky130_fd_sc_hd__buf_1
XFILLER_22_70 vssd vssd vccd vccd sky130_fd_sc_hd__decap_3
XFILLER_7_134 vssd vssd vccd vccd sky130_fd_sc_hd__decap_3
XFILLER_21_6 vssd vssd vccd vccd sky130_fd_sc_hd__decap_3
XFILLER_8_83 vssd vssd vccd vccd sky130_fd_sc_hd__fill_1
XFILLER_27_15 vssd vssd vccd vccd sky130_fd_sc_hd__decap_3
XFILLER_27_48 vssd vssd vccd vccd sky130_fd_sc_hd__decap_3
XFILLER_4_159 vssd vssd vccd vccd sky130_fd_sc_hd__decap_3
XTAP_TAPCELL_ROW_4_73 vssd vccd sky130_fd_sc_hd__tapvpwrvgnd_1
XFILLER_1_129 vssd vssd vccd vccd sky130_fd_sc_hd__decap_3
Xfanout29 net34 vssd vssd vccd vccd net29 sky130_fd_sc_hd__clkbuf_2
XFILLER_0_162 vssd vssd vccd vccd sky130_fd_sc_hd__decap_3
XFILLER_28_91 vssd vssd vccd vccd sky130_fd_sc_hd__decap_3
XFILLER_24_27 vssd vssd vccd vccd sky130_fd_sc_hd__fill_1
XFILLER_24_49 vssd vssd vccd vccd sky130_fd_sc_hd__decap_3
X_284_ net37 _002_ net28 vssd vssd vccd vccd regs\[15\]\[2\] sky130_fd_sc_hd__dfrtp_1
Xinput8 wdata[1] vssd vssd vccd vccd net8 sky130_fd_sc_hd__buf_1
XFILLER_10_29 vssd vssd vccd vccd sky130_fd_sc_hd__decap_3
XFILLER_27_136 vssd vssd vccd vccd sky130_fd_sc_hd__decap_3
XFILLER_27_169 vssd vssd vccd vccd sky130_fd_sc_hd__decap_3
XFILLER_18_114 vssd vssd vccd vccd sky130_fd_sc_hd__decap_3
X_336_ net37 _054_ net28 vssd vssd vccd vccd regs\[11\]\[2\] sky130_fd_sc_hd__dfrtp_1
X_267_ net52 _085_ vssd vssd vccd vccd _138_ sky130_fd_sc_hd__nand2_2
X_198_ regs\[4\]\[3\] _074_ _082_ regs\[6\]\[3\] _117_ vssd vssd vccd vccd _118_ sky130_fd_sc_hd__a221o_1
XFILLER_24_128 vssd vssd vccd vccd sky130_fd_sc_hd__decap_3
XTAP_TAPCELL_ROW_19_120 vssd vccd sky130_fd_sc_hd__tapvpwrvgnd_1
XFILLER_11_72 vssd vssd vccd vccd sky130_fd_sc_hd__decap_3
XFILLER_15_128 vssd vssd vccd vccd sky130_fd_sc_hd__decap_3
XFILLER_16_9 vssd vssd vccd vccd sky130_fd_sc_hd__decap_3
XTAP_TAPCELL_ROW_11_94 vssd vccd sky130_fd_sc_hd__tapvpwrvgnd_1
XFILLER_14_161 vssd vssd vccd vccd sky130_fd_sc_hd__decap_3
XFILLER_21_109 vssd vssd vccd vccd sky130_fd_sc_hd__decap_3
X_319_ net41 _037_ net32 vssd vssd vccd vccd regs\[7\]\[1\] sky130_fd_sc_hd__dfrtp_1
Xinput11 we vssd vssd vccd vccd net11 sky130_fd_sc_hd__clkbuf_1
XTAP_TAPCELL_ROW_7_84 vssd vccd sky130_fd_sc_hd__tapvpwrvgnd_1
XFILLER_12_109 vssd vssd vccd vccd sky130_fd_sc_hd__decap_3
XFILLER_20_131 vssd vssd vccd vccd sky130_fd_sc_hd__decap_3
XFILLER_11_131 vssd vssd vccd vccd sky130_fd_sc_hd__decap_3
XFILLER_14_6 vssd vssd vccd vccd sky130_fd_sc_hd__fill_1
XFILLER_22_82 vssd vssd vccd vccd sky130_fd_sc_hd__fill_2
XFILLER_7_113 vssd vssd vccd vccd sky130_fd_sc_hd__fill_1
XFILLER_27_27 vssd vssd vccd vccd sky130_fd_sc_hd__decap_3
XFILLER_4_105 vssd vssd vccd vccd sky130_fd_sc_hd__decap_3
XFILLER_4_138 vssd vssd vccd vccd sky130_fd_sc_hd__fill_2
XTAP_TAPCELL_ROW_4_74 vssd vccd sky130_fd_sc_hd__tapvpwrvgnd_1
XFILLER_12_3 vssd vssd vccd vccd sky130_fd_sc_hd__fill_2
XFILLER_1_119 vssd vssd vccd vccd sky130_fd_sc_hd__fill_1
XFILLER_0_141 vssd vssd vccd vccd sky130_fd_sc_hd__decap_3
XFILLER_28_81 vssd vssd vccd vccd sky130_fd_sc_hd__decap_3
XFILLER_14_83 vssd vssd vccd vccd sky130_fd_sc_hd__fill_1
Xinput9 wdata[2] vssd vssd vccd vccd net9 sky130_fd_sc_hd__buf_1
X_283_ net35 _001_ net26 vssd vssd vccd vccd regs\[15\]\[1\] sky130_fd_sc_hd__dfrtp_1
XTAP_TAPCELL_ROW_1_64 vssd vccd sky130_fd_sc_hd__tapvpwrvgnd_1
XFILLER_27_148 vssd vssd vccd vccd sky130_fd_sc_hd__decap_3
XFILLER_18_137 vssd vssd vccd vccd sky130_fd_sc_hd__decap_3
X_335_ net36 _053_ net27 vssd vssd vccd vccd regs\[11\]\[1\] sky130_fd_sc_hd__dfrtp_1
X_266_ net53 regs\[11\]\[3\] _137_ vssd vssd vccd vccd _055_ sky130_fd_sc_hd__mux2_1
X_197_ regs\[2\]\[3\] _075_ _077_ regs\[5\]\[3\] vssd vssd vccd vccd _117_ sky130_fd_sc_hd__a22o_1
XFILLER_21_29 vssd vssd vccd vccd sky130_fd_sc_hd__decap_3
XPHY_EDGE_ROW_10_Right_10 vssd vssd vccd vccd sky130_fd_sc_hd__decap_3
XFILLER_11_40 vssd vssd vccd vccd sky130_fd_sc_hd__decap_3
XFILLER_11_84 vssd vssd vccd vccd sky130_fd_sc_hd__decap_3
Xmax_cap16 net17 vssd vssd vccd vccd net16 sky130_fd_sc_hd__buf_1
XTAP_TAPCELL_ROW_11_95 vssd vccd sky130_fd_sc_hd__tapvpwrvgnd_1
X_318_ net41 _036_ net32 vssd vssd vccd vccd regs\[7\]\[0\] sky130_fd_sc_hd__dfrtp_1
X_249_ net23 regs\[8\]\[1\] _134_ vssd vssd vccd vccd _041_ sky130_fd_sc_hd__mux2_1
XFILLER_16_18 vssd vssd vccd vccd sky130_fd_sc_hd__decap_3
XFILLER_16_29 vssd vssd vccd vccd sky130_fd_sc_hd__fill_2
XTAP_TAPCELL_ROW_22_127 vssd vccd sky130_fd_sc_hd__tapvpwrvgnd_1
XFILLER_11_165 vssd vssd vccd vccd sky130_fd_sc_hd__decap_3
XFILLER_27_39 vssd vssd vccd vccd sky130_fd_sc_hd__decap_3
XFILLER_8_74 vssd vssd vccd vccd sky130_fd_sc_hd__decap_3
XFILLER_17_50 vssd vssd vccd vccd sky130_fd_sc_hd__decap_3
XTAP_TAPCELL_ROW_4_75 vssd vccd sky130_fd_sc_hd__tapvpwrvgnd_1
XPHY_EDGE_ROW_8_Right_8 vssd vssd vccd vccd sky130_fd_sc_hd__decap_3
XFILLER_0_131 vssd vssd vccd vccd sky130_fd_sc_hd__decap_3
XFILLER_0_153 vssd vssd vccd vccd sky130_fd_sc_hd__decap_3
XFILLER_28_60 vssd vssd vccd vccd sky130_fd_sc_hd__decap_3
XFILLER_5_31 vssd vssd vccd vccd sky130_fd_sc_hd__decap_3
XFILLER_24_18 vssd vssd vccd vccd sky130_fd_sc_hd__decap_3
XFILLER_24_29 vssd vssd vccd vccd sky130_fd_sc_hd__decap_3
XFILLER_14_73 vssd vssd vccd vccd sky130_fd_sc_hd__fill_1
X_282_ net36 _000_ net27 vssd vssd vccd vccd regs\[15\]\[0\] sky130_fd_sc_hd__dfrtp_1
XTAP_TAPCELL_ROW_1_65 vssd vccd sky130_fd_sc_hd__tapvpwrvgnd_1
XFILLER_18_105 vssd vssd vccd vccd sky130_fd_sc_hd__decap_3
XFILLER_26_171 vssd vssd vccd vccd sky130_fd_sc_hd__fill_1
XFILLER_4_6 vssd vssd vccd vccd sky130_fd_sc_hd__fill_1
X_334_ net35 _052_ net26 vssd vssd vccd vccd regs\[11\]\[0\] sky130_fd_sc_hd__dfrtp_1
XFILLER_2_21 vssd vssd vccd vccd sky130_fd_sc_hd__decap_3
XFILLER_2_32 vssd vssd vccd vccd sky130_fd_sc_hd__decap_3
X_265_ net20 regs\[11\]\[2\] _137_ vssd vssd vccd vccd _054_ sky130_fd_sc_hd__mux2_1
X_196_ net51 net14 _115_ _116_ vssd vssd vccd vccd _006_ sky130_fd_sc_hd__a22o_1
XFILLER_15_119 vssd vssd vccd vccd sky130_fd_sc_hd__decap_3
Xmax_cap17 _078_ vssd vssd vccd vccd net17 sky130_fd_sc_hd__buf_1
XTAP_TAPCELL_ROW_25_136 vssd vccd sky130_fd_sc_hd__tapvpwrvgnd_1
XTAP_TAPCELL_ROW_11_96 vssd vccd sky130_fd_sc_hd__tapvpwrvgnd_1
XFILLER_11_52 vssd vssd vccd vccd sky130_fd_sc_hd__decap_3
XFILLER_11_63 vssd vssd vccd vccd sky130_fd_sc_hd__decap_3
XFILLER_11_96 vssd vssd vccd vccd sky130_fd_sc_hd__decap_3
XFILLER_14_130 vssd vssd vccd vccd sky130_fd_sc_hd__decap_3
XFILLER_2_3 vssd vssd vccd vccd sky130_fd_sc_hd__decap_3
XPHY_EDGE_ROW_10_Left_39 vssd vssd vccd vccd sky130_fd_sc_hd__decap_3
X_317_ net40 _035_ net31 vssd vssd vccd vccd regs\[6\]\[3\] sky130_fd_sc_hd__dfrtp_1
X_248_ net24 regs\[8\]\[0\] _134_ vssd vssd vccd vccd _040_ sky130_fd_sc_hd__mux2_1
X_179_ regs\[1\]\[1\] _071_ _085_ regs\[12\]\[1\] vssd vssd vccd vccd _101_ sky130_fd_sc_hd__a22o_1
XPHY_EDGE_ROW_26_Left_55 vssd vssd vccd vccd sky130_fd_sc_hd__decap_3
XTAP_TAPCELL_ROW_22_128 vssd vccd sky130_fd_sc_hd__tapvpwrvgnd_1
XFILLER_11_111 vssd vssd vccd vccd sky130_fd_sc_hd__fill_1
XFILLER_11_122 vssd vssd vccd vccd sky130_fd_sc_hd__decap_3
XFILLER_22_73 vssd vssd vccd vccd sky130_fd_sc_hd__decap_3
XFILLER_7_104 vssd vssd vccd vccd sky130_fd_sc_hd__decap_3
XFILLER_7_137 vssd vssd vccd vccd sky130_fd_sc_hd__decap_3
XFILLER_27_18 vssd vssd vccd vccd sky130_fd_sc_hd__decap_3
XFILLER_6_170 vssd vssd vccd vccd sky130_fd_sc_hd__fill_2
XFILLER_3_162 vssd vssd vccd vccd sky130_fd_sc_hd__decap_3
XPHY_EDGE_ROW_13_Left_42 vssd vssd vccd vccd sky130_fd_sc_hd__decap_3
XFILLER_0_165 vssd vssd vccd vccd sky130_fd_sc_hd__decap_3
XFILLER_28_50 vssd vssd vccd vccd sky130_fd_sc_hd__decap_3
XFILLER_28_72 vssd vssd vccd vccd sky130_fd_sc_hd__decap_3
XFILLER_28_94 vssd vssd vccd vccd sky130_fd_sc_hd__decap_3
XFILLER_5_65 vssd vssd vccd vccd sky130_fd_sc_hd__fill_2
XFILLER_5_87 vssd vssd vccd vccd sky130_fd_sc_hd__decap_3
XFILLER_14_52 vssd vssd vccd vccd sky130_fd_sc_hd__decap_3
X_281_ net53 regs\[14\]\[3\] _140_ vssd vssd vccd vccd _067_ sky130_fd_sc_hd__mux2_1
XTAP_TAPCELL_ROW_1_66 vssd vccd sky130_fd_sc_hd__tapvpwrvgnd_1
XFILLER_18_117 vssd vssd vccd vccd sky130_fd_sc_hd__fill_2
XFILLER_18_128 vssd vssd vccd vccd sky130_fd_sc_hd__decap_3
XFILLER_27_139 vssd vssd vccd vccd sky130_fd_sc_hd__decap_3
XTAP_TAPCELL_ROW_28_145 vssd vccd sky130_fd_sc_hd__tapvpwrvgnd_1
XFILLER_25_51 vssd vssd vccd vccd sky130_fd_sc_hd__decap_3
XFILLER_26_150 vssd vssd vccd vccd sky130_fd_sc_hd__decap_3
X_333_ net37 _051_ net28 vssd vssd vccd vccd regs\[10\]\[3\] sky130_fd_sc_hd__dfrtp_1
X_264_ net22 regs\[11\]\[1\] _137_ vssd vssd vccd vccd _053_ sky130_fd_sc_hd__mux2_1
X_195_ regs\[0\]\[2\] _079_ net50 vssd vssd vccd vccd _116_ sky130_fd_sc_hd__o21ba_1
XTAP_TAPCELL_ROW_25_137 vssd vccd sky130_fd_sc_hd__tapvpwrvgnd_1
XFILLER_11_31 vssd vssd vccd vccd sky130_fd_sc_hd__decap_3
XFILLER_11_75 vssd vssd vccd vccd sky130_fd_sc_hd__decap_3
XFILLER_14_164 vssd vssd vccd vccd sky130_fd_sc_hd__fill_2
XPHY_EDGE_ROW_1_Left_30 vssd vssd vccd vccd sky130_fd_sc_hd__decap_3
X_316_ net40 _034_ net31 vssd vssd vccd vccd regs\[6\]\[2\] sky130_fd_sc_hd__dfrtp_1
X_247_ net52 _084_ vssd vssd vccd vccd _134_ sky130_fd_sc_hd__nand2_2
XFILLER_20_134 vssd vssd vccd vccd sky130_fd_sc_hd__decap_3
XFILLER_28_3 vssd vssd vccd vccd sky130_fd_sc_hd__decap_3
X_178_ regs\[15\]\[1\] _068_ _088_ regs\[13\]\[1\] vssd vssd vccd vccd _100_ sky130_fd_sc_hd__a22o_1
XTAP_TAPCELL_ROW_22_129 vssd vccd sky130_fd_sc_hd__tapvpwrvgnd_1
XFILLER_11_134 vssd vssd vccd vccd sky130_fd_sc_hd__fill_2
XFILLER_8_32 vssd vssd vccd vccd sky130_fd_sc_hd__decap_3
XFILLER_4_108 vssd vssd vccd vccd sky130_fd_sc_hd__decap_3
XFILLER_0_122 vssd vssd vccd vccd sky130_fd_sc_hd__decap_3
XFILLER_0_144 vssd vssd vccd vccd sky130_fd_sc_hd__decap_3
XFILLER_10_3 vssd vssd vccd vccd sky130_fd_sc_hd__decap_3
X_280_ net20 regs\[14\]\[2\] _140_ vssd vssd vccd vccd _066_ sky130_fd_sc_hd__mux2_1
XFILLER_26_162 vssd vssd vccd vccd sky130_fd_sc_hd__decap_3
XFILLER_2_12 vssd vssd vccd vccd sky130_fd_sc_hd__decap_3
X_332_ net37 _050_ net28 vssd vssd vccd vccd regs\[10\]\[2\] sky130_fd_sc_hd__dfrtp_1
X_263_ net24 regs\[11\]\[0\] _137_ vssd vssd vccd vccd _052_ sky130_fd_sc_hd__mux2_1
X_194_ _108_ _110_ _114_ vssd vssd vccd vccd _115_ sky130_fd_sc_hd__or3_1
XTAP_TAPCELL_ROW_28_146 vssd vccd sky130_fd_sc_hd__tapvpwrvgnd_1
Xmax_cap19 _071_ vssd vssd vccd vccd net19 sky130_fd_sc_hd__clkbuf_2
XFILLER_11_43 vssd vssd vccd vccd sky130_fd_sc_hd__decap_3
XFILLER_11_87 vssd vssd vccd vccd sky130_fd_sc_hd__decap_3
XFILLER_14_110 vssd vssd vccd vccd sky130_fd_sc_hd__fill_2
XTAP_TAPCELL_ROW_25_138 vssd vccd sky130_fd_sc_hd__tapvpwrvgnd_1
X_315_ net39 _033_ net30 vssd vssd vccd vccd regs\[6\]\[1\] sky130_fd_sc_hd__dfrtp_1
X_246_ net54 regs\[7\]\[3\] _133_ vssd vssd vccd vccd _039_ sky130_fd_sc_hd__mux2_1
X_177_ regs\[5\]\[1\] _077_ _092_ regs\[11\]\[1\] _097_ vssd vssd vccd vccd _099_
+ sky130_fd_sc_hd__a221o_1
XFILLER_22_42 vssd vssd vccd vccd sky130_fd_sc_hd__fill_1
XFILLER_8_77 vssd vssd vccd vccd sky130_fd_sc_hd__decap_3
X_229_ net22 regs\[4\]\[1\] _130_ vssd vssd vccd vccd _025_ sky130_fd_sc_hd__mux2_1
XFILLER_17_53 vssd vssd vccd vccd sky130_fd_sc_hd__decap_3
XFILLER_3_131 vssd vssd vccd vccd sky130_fd_sc_hd__decap_3
XFILLER_0_134 vssd vssd vccd vccd sky130_fd_sc_hd__decap_3
XFILLER_0_156 vssd vssd vccd vccd sky130_fd_sc_hd__decap_3
XFILLER_28_41 vssd vssd vccd vccd sky130_fd_sc_hd__decap_3
XFILLER_28_63 vssd vssd vccd vccd sky130_fd_sc_hd__decap_3
XFILLER_28_85 vssd vssd vccd vccd sky130_fd_sc_hd__decap_3
XPHY_EDGE_ROW_17_Right_17 vssd vssd vccd vccd sky130_fd_sc_hd__decap_3
XPHY_EDGE_ROW_26_Right_26 vssd vssd vccd vccd sky130_fd_sc_hd__decap_3
XFILLER_5_12 vssd vssd vccd vccd sky130_fd_sc_hd__decap_3
XFILLER_5_34 vssd vssd vccd vccd sky130_fd_sc_hd__fill_2
XFILLER_14_32 vssd vssd vccd vccd sky130_fd_sc_hd__decap_3
XFILLER_18_108 vssd vssd vccd vccd sky130_fd_sc_hd__decap_3
XFILLER_26_141 vssd vssd vccd vccd sky130_fd_sc_hd__decap_3
X_331_ net37 _049_ net28 vssd vssd vccd vccd regs\[10\]\[1\] sky130_fd_sc_hd__dfrtp_1
X_262_ net52 _092_ vssd vssd vccd vccd _137_ sky130_fd_sc_hd__nand2_2
X_193_ regs\[11\]\[2\] _092_ _111_ _113_ vssd vssd vccd vccd _114_ sky130_fd_sc_hd__a211o_1
XTAP_TAPCELL_ROW_28_147 vssd vccd sky130_fd_sc_hd__tapvpwrvgnd_1
XFILLER_17_163 vssd vssd vccd vccd sky130_fd_sc_hd__fill_1
XFILLER_2_24 vssd vssd vccd vccd sky130_fd_sc_hd__decap_3
XFILLER_11_55 vssd vssd vccd vccd sky130_fd_sc_hd__fill_1
XFILLER_11_66 vssd vssd vccd vccd sky130_fd_sc_hd__decap_3
XFILLER_11_99 vssd vssd vccd vccd sky130_fd_sc_hd__fill_1
XFILLER_23_100 vssd vssd vccd vccd sky130_fd_sc_hd__decap_3
XFILLER_2_6 vssd vssd vccd vccd sky130_fd_sc_hd__decap_3
XFILLER_14_133 vssd vssd vccd vccd sky130_fd_sc_hd__decap_3
X_314_ net39 _032_ net30 vssd vssd vccd vccd regs\[6\]\[0\] sky130_fd_sc_hd__dfrtp_1
X_245_ net21 regs\[7\]\[2\] _133_ vssd vssd vccd vccd _038_ sky130_fd_sc_hd__mux2_1
X_176_ regs\[9\]\[1\] _089_ _091_ regs\[14\]\[1\] vssd vssd vccd vccd _098_ sky130_fd_sc_hd__a22o_1
XFILLER_20_158 vssd vssd vccd vccd sky130_fd_sc_hd__fill_1
XFILLER_20_169 vssd vssd vccd vccd sky130_fd_sc_hd__decap_3
XFILLER_0_3 vssd vssd vccd vccd sky130_fd_sc_hd__decap_3
XFILLER_11_125 vssd vssd vccd vccd sky130_fd_sc_hd__decap_3
XFILLER_11_169 vssd vssd vccd vccd sky130_fd_sc_hd__decap_3
XFILLER_22_21 vssd vssd vccd vccd sky130_fd_sc_hd__decap_3
XFILLER_22_76 vssd vssd vccd vccd sky130_fd_sc_hd__decap_3
XFILLER_7_107 vssd vssd vccd vccd sky130_fd_sc_hd__decap_3
XFILLER_8_12 vssd vssd vccd vccd sky130_fd_sc_hd__decap_3
X_228_ net25 regs\[4\]\[0\] _130_ vssd vssd vccd vccd _024_ sky130_fd_sc_hd__mux2_1
X_159_ net56 net44 net46 net49 vssd vssd vccd vccd _082_ sky130_fd_sc_hd__and4bb_1
XFILLER_3_165 vssd vssd vccd vccd sky130_fd_sc_hd__decap_3
XFILLER_0_113 vssd vssd vccd vccd sky130_fd_sc_hd__decap_3
XFILLER_28_53 vssd vssd vccd vccd sky130_fd_sc_hd__decap_3
XFILLER_28_75 vssd vssd vccd vccd sky130_fd_sc_hd__decap_3
XFILLER_28_97 vssd vssd vccd vccd sky130_fd_sc_hd__decap_3
XPHY_EDGE_ROW_17_Left_46 vssd vssd vccd vccd sky130_fd_sc_hd__decap_3
XFILLER_14_11 vssd vssd vccd vccd sky130_fd_sc_hd__decap_3
XFILLER_14_55 vssd vssd vccd vccd sky130_fd_sc_hd__decap_3
XFILLER_25_21 vssd vssd vccd vccd sky130_fd_sc_hd__fill_1
XFILLER_25_54 vssd vssd vccd vccd sky130_fd_sc_hd__fill_2
XFILLER_25_98 vssd vssd vccd vccd sky130_fd_sc_hd__decap_3
XFILLER_26_153 vssd vssd vccd vccd sky130_fd_sc_hd__decap_3
X_330_ net37 _048_ net28 vssd vssd vccd vccd regs\[10\]\[0\] sky130_fd_sc_hd__dfrtp_1
X_261_ net53 regs\[10\]\[3\] _136_ vssd vssd vccd vccd _051_ sky130_fd_sc_hd__mux2_1
X_192_ regs\[15\]\[2\] _068_ _085_ regs\[12\]\[2\] _112_ vssd vssd vccd vccd _113_
+ sky130_fd_sc_hd__a221o_1
XTAP_TAPCELL_ROW_28_148 vssd vccd sky130_fd_sc_hd__tapvpwrvgnd_1
XFILLER_11_34 vssd vssd vccd vccd sky130_fd_sc_hd__decap_3
XFILLER_11_78 vssd vssd vccd vccd sky130_fd_sc_hd__decap_3
XFILLER_28_6 vssd vssd vccd vccd sky130_fd_sc_hd__decap_3
X_313_ net40 _031_ net31 vssd vssd vccd vccd regs\[5\]\[3\] sky130_fd_sc_hd__dfrtp_1
X_244_ net23 regs\[7\]\[1\] _133_ vssd vssd vccd vccd _037_ sky130_fd_sc_hd__mux2_1
X_175_ regs\[2\]\[1\] _075_ _081_ regs\[3\]\[1\] vssd vssd vccd vccd _097_ sky130_fd_sc_hd__a22o_1
XFILLER_20_137 vssd vssd vccd vccd sky130_fd_sc_hd__decap_3
XFILLER_11_159 vssd vssd vccd vccd sky130_fd_sc_hd__decap_3
XPHY_EDGE_ROW_5_Left_34 vssd vssd vccd vccd sky130_fd_sc_hd__decap_3
XFILLER_8_35 vssd vssd vccd vccd sky130_fd_sc_hd__fill_2
XFILLER_8_46 vssd vssd vccd vccd sky130_fd_sc_hd__fill_2
XFILLER_8_68 vssd vssd vccd vccd sky130_fd_sc_hd__decap_3
X_227_ net50 _074_ vssd vssd vccd vccd _130_ sky130_fd_sc_hd__nand2_2
X_158_ net44 net47 net48 net55 vssd vssd vccd vccd _081_ sky130_fd_sc_hd__and4bb_2
XFILLER_17_66 vssd vssd vccd vccd sky130_fd_sc_hd__decap_3
XFILLER_0_91 vssd vssd vccd vccd sky130_fd_sc_hd__decap_3
XPHY_EDGE_ROW_3_Right_3 vssd vssd vccd vccd sky130_fd_sc_hd__decap_3
XFILLER_0_125 vssd vssd vccd vccd sky130_fd_sc_hd__decap_3
XFILLER_0_147 vssd vssd vccd vccd sky130_fd_sc_hd__decap_3
XFILLER_0_169 vssd vssd vccd vccd sky130_fd_sc_hd__decap_3
XFILLER_28_21 vssd vssd vccd vccd sky130_fd_sc_hd__decap_3
XFILLER_28_32 vssd vssd vccd vccd sky130_fd_sc_hd__decap_3
XFILLER_5_25 vssd vssd vccd vccd sky130_fd_sc_hd__decap_3
XFILLER_10_6 vssd vssd vccd vccd sky130_fd_sc_hd__decap_3
XFILLER_25_77 vssd vssd vccd vccd sky130_fd_sc_hd__fill_1
XFILLER_26_165 vssd vssd vccd vccd sky130_fd_sc_hd__decap_3
X_260_ net20 regs\[10\]\[2\] _136_ vssd vssd vccd vccd _050_ sky130_fd_sc_hd__mux2_1
XTAP_TAPCELL_ROW_28_149 vssd vccd sky130_fd_sc_hd__tapvpwrvgnd_1
XFILLER_2_15 vssd vssd vccd vccd sky130_fd_sc_hd__decap_3
X_191_ regs\[9\]\[2\] _089_ _091_ regs\[14\]\[2\] vssd vssd vccd vccd _112_ sky130_fd_sc_hd__a22o_1
XFILLER_11_46 vssd vssd vccd vccd sky130_fd_sc_hd__decap_3
XFILLER_11_57 vssd vssd vccd vccd sky130_fd_sc_hd__decap_3
XFILLER_23_113 vssd vssd vccd vccd sky130_fd_sc_hd__decap_3
X_312_ net40 _030_ net31 vssd vssd vccd vccd regs\[5\]\[2\] sky130_fd_sc_hd__dfrtp_1
X_243_ net25 regs\[7\]\[0\] _133_ vssd vssd vccd vccd _036_ sky130_fd_sc_hd__mux2_1
X_174_ net50 net12 _095_ _096_ vssd vssd vccd vccd _004_ sky130_fd_sc_hd__a22o_1
XFILLER_20_105 vssd vssd vccd vccd sky130_fd_sc_hd__decap_3
XPHY_EDGE_ROW_21_Left_50 vssd vssd vccd vccd sky130_fd_sc_hd__decap_3
XFILLER_22_12 vssd vssd vccd vccd sky130_fd_sc_hd__decap_3
XFILLER_19_3 vssd vssd vccd vccd sky130_fd_sc_hd__decap_3
XFILLER_8_25 vssd vssd vccd vccd sky130_fd_sc_hd__decap_3
X_226_ net54 regs\[3\]\[3\] _129_ vssd vssd vccd vccd _023_ sky130_fd_sc_hd__mux2_1
X_157_ regs\[15\]\[0\] _068_ _077_ regs\[5\]\[0\] _078_ vssd vssd vccd vccd _080_
+ sky130_fd_sc_hd__a221o_1
XFILLER_3_134 vssd vssd vccd vccd sky130_fd_sc_hd__fill_2
XFILLER_3_156 vssd vssd vccd vccd sky130_fd_sc_hd__decap_3
XFILLER_0_81 vssd vssd vccd vccd sky130_fd_sc_hd__decap_3
X_209_ net23 regs\[0\]\[1\] _126_ vssd vssd vccd vccd _009_ sky130_fd_sc_hd__mux2_1
XFILLER_0_137 vssd vssd vccd vccd sky130_fd_sc_hd__decap_3
XFILLER_0_159 vssd vssd vccd vccd sky130_fd_sc_hd__decap_3
XFILLER_28_44 vssd vssd vccd vccd sky130_fd_sc_hd__decap_3
XFILLER_28_66 vssd vssd vccd vccd sky130_fd_sc_hd__decap_3
XFILLER_28_88 vssd vssd vccd vccd sky130_fd_sc_hd__decap_3
XFILLER_5_15 vssd vssd vccd vccd sky130_fd_sc_hd__fill_1
XPHY_EDGE_ROW_13_Right_13 vssd vssd vccd vccd sky130_fd_sc_hd__decap_3
XPHY_EDGE_ROW_22_Right_22 vssd vssd vccd vccd sky130_fd_sc_hd__decap_3
XFILLER_14_24 vssd vssd vccd vccd sky130_fd_sc_hd__decap_3
XFILLER_14_35 vssd vssd vccd vccd sky130_fd_sc_hd__fill_2
XFILLER_14_46 vssd vssd vccd vccd sky130_fd_sc_hd__decap_3
XFILLER_25_12 vssd vssd vccd vccd sky130_fd_sc_hd__decap_3
XFILLER_26_144 vssd vssd vccd vccd sky130_fd_sc_hd__decap_3
XFILLER_17_122 vssd vssd vccd vccd sky130_fd_sc_hd__decap_3
XFILLER_25_45 vssd vssd vccd vccd sky130_fd_sc_hd__decap_3
XFILLER_2_27 vssd vssd vccd vccd sky130_fd_sc_hd__fill_1
X_190_ regs\[10\]\[2\] _086_ _088_ regs\[13\]\[2\] vssd vssd vccd vccd _111_ sky130_fd_sc_hd__a22o_1
XFILLER_23_103 vssd vssd vccd vccd sky130_fd_sc_hd__decap_3
XFILLER_23_169 vssd vssd vccd vccd sky130_fd_sc_hd__decap_3
XFILLER_11_69 vssd vssd vccd vccd sky130_fd_sc_hd__decap_3
XFILLER_14_136 vssd vssd vccd vccd sky130_fd_sc_hd__decap_3
XFILLER_2_9 vssd vssd vccd vccd sky130_fd_sc_hd__decap_3
X_311_ net36 _029_ net27 vssd vssd vccd vccd regs\[5\]\[1\] sky130_fd_sc_hd__dfrtp_1
X_242_ net51 _070_ vssd vssd vccd vccd _133_ sky130_fd_sc_hd__nand2_1
X_173_ regs\[0\]\[0\] _079_ net50 vssd vssd vccd vccd _096_ sky130_fd_sc_hd__o21ba_1
XTAP_TAPCELL_ROW_16_109 vssd vccd sky130_fd_sc_hd__tapvpwrvgnd_1
XFILLER_20_128 vssd vssd vccd vccd sky130_fd_sc_hd__decap_3
XFILLER_0_6 vssd vssd vccd vccd sky130_fd_sc_hd__decap_3
XFILLER_11_128 vssd vssd vccd vccd sky130_fd_sc_hd__decap_3
XFILLER_22_24 vssd vssd vccd vccd sky130_fd_sc_hd__decap_3
XFILLER_22_79 vssd vssd vccd vccd sky130_fd_sc_hd__decap_3
XFILLER_6_110 vssd vssd vccd vccd sky130_fd_sc_hd__decap_3
XFILLER_6_132 vssd vssd vccd vccd sky130_fd_sc_hd__decap_3
XFILLER_8_15 vssd vssd vccd vccd sky130_fd_sc_hd__fill_1
X_225_ net21 regs\[3\]\[2\] _129_ vssd vssd vccd vccd _022_ sky130_fd_sc_hd__mux2_1
X_156_ net49 net56 net45 net46 vssd vssd vccd vccd _079_ sky130_fd_sc_hd__or4_2
XFILLER_3_113 vssd vssd vccd vccd sky130_fd_sc_hd__decap_3
XFILLER_0_60 vssd vssd vccd vccd sky130_fd_sc_hd__decap_3
X_208_ net24 regs\[0\]\[0\] _126_ vssd vssd vccd vccd _008_ sky130_fd_sc_hd__mux2_1
XFILLER_0_116 vssd vssd vccd vccd sky130_fd_sc_hd__decap_3
XFILLER_28_12 vssd vssd vccd vccd sky130_fd_sc_hd__decap_3
XFILLER_28_78 vssd vssd vccd vccd sky130_fd_sc_hd__decap_3
XFILLER_14_14 vssd vssd vccd vccd sky130_fd_sc_hd__decap_3
XFILLER_14_58 vssd vssd vccd vccd sky130_fd_sc_hd__fill_1
XFILLER_6_70 vssd vssd vccd vccd sky130_fd_sc_hd__decap_3
XFILLER_26_101 vssd vssd vccd vccd sky130_fd_sc_hd__decap_3
XFILLER_26_156 vssd vssd vccd vccd sky130_fd_sc_hd__decap_3
XTAP_TAPCELL_ROW_19_118 vssd vccd sky130_fd_sc_hd__tapvpwrvgnd_1
XFILLER_11_37 vssd vssd vccd vccd sky130_fd_sc_hd__decap_3
XFILLER_14_104 vssd vssd vccd vccd sky130_fd_sc_hd__decap_3
X_310_ net36 _028_ net27 vssd vssd vccd vccd regs\[5\]\[0\] sky130_fd_sc_hd__dfrtp_1
XFILLER_22_170 vssd vssd vccd vccd sky130_fd_sc_hd__fill_2
XFILLER_28_9 vssd vssd vccd vccd sky130_fd_sc_hd__decap_3
X_241_ net54 regs\[6\]\[3\] _132_ vssd vssd vccd vccd _035_ sky130_fd_sc_hd__mux2_1
X_172_ _072_ _076_ _094_ vssd vssd vccd vccd _095_ sky130_fd_sc_hd__or3_1
XTAP_TAPCELL_ROW_21_124 vssd vccd sky130_fd_sc_hd__tapvpwrvgnd_1
X_224_ net22 regs\[3\]\[1\] _129_ vssd vssd vccd vccd _021_ sky130_fd_sc_hd__mux2_1
X_155_ net49 net56 net45 net46 vssd vssd vccd vccd _078_ sky130_fd_sc_hd__nor4_1
XFILLER_26_6 vssd vssd vccd vccd sky130_fd_sc_hd__decap_3
XFILLER_17_47 vssd vssd vccd vccd sky130_fd_sc_hd__decap_3
XFILLER_17_69 vssd vssd vccd vccd sky130_fd_sc_hd__decap_3
XFILLER_3_169 vssd vssd vccd vccd sky130_fd_sc_hd__decap_3
XPHY_EDGE_ROW_9_Left_38 vssd vssd vccd vccd sky130_fd_sc_hd__decap_3
XFILLER_24_3 vssd vssd vccd vccd sky130_fd_sc_hd__decap_3
X_207_ net51 net16 vssd vssd vccd vccd _126_ sky130_fd_sc_hd__nand2_2
XFILLER_0_128 vssd vssd vccd vccd sky130_fd_sc_hd__decap_3
XFILLER_0_72 vssd vssd vccd vccd sky130_fd_sc_hd__decap_3
XFILLER_0_94 vssd vssd vccd vccd sky130_fd_sc_hd__decap_3
XFILLER_28_24 vssd vssd vccd vccd sky130_fd_sc_hd__decap_3
XFILLER_28_35 vssd vssd vccd vccd sky130_fd_sc_hd__decap_3
XFILLER_28_57 vssd vssd vccd vccd sky130_fd_sc_hd__decap_3
XFILLER_9_81 vssd vssd vccd vccd sky130_fd_sc_hd__fill_2
XFILLER_10_9 vssd vssd vccd vccd sky130_fd_sc_hd__decap_3
XFILLER_5_28 vssd vssd vccd vccd sky130_fd_sc_hd__decap_3
XPHY_EDGE_ROW_7_Right_7 vssd vssd vccd vccd sky130_fd_sc_hd__decap_3
XFILLER_6_82 vssd vssd vccd vccd sky130_fd_sc_hd__fill_2
XFILLER_26_168 vssd vssd vccd vccd sky130_fd_sc_hd__decap_3
XFILLER_2_18 vssd vssd vccd vccd sky130_fd_sc_hd__decap_3
XFILLER_2_29 vssd vssd vccd vccd sky130_fd_sc_hd__decap_3
XTAP_TAPCELL_ROW_19_119 vssd vccd sky130_fd_sc_hd__tapvpwrvgnd_1
XFILLER_11_49 vssd vssd vccd vccd sky130_fd_sc_hd__decap_3
XFILLER_23_116 vssd vssd vccd vccd sky130_fd_sc_hd__fill_2
XFILLER_23_138 vssd vssd vccd vccd sky130_fd_sc_hd__decap_3
X_240_ net21 regs\[6\]\[2\] _132_ vssd vssd vccd vccd _034_ sky130_fd_sc_hd__mux2_1
X_171_ regs\[8\]\[0\] _084_ _087_ _093_ _083_ vssd vssd vccd vccd _094_ sky130_fd_sc_hd__a2111o_1
XTAP_TAPCELL_ROW_24_133 vssd vccd sky130_fd_sc_hd__tapvpwrvgnd_1
XFILLER_11_108 vssd vssd vccd vccd sky130_fd_sc_hd__decap_3
XFILLER_3_50 vssd vssd vccd vccd sky130_fd_sc_hd__decap_3
XFILLER_3_72 vssd vssd vccd vccd sky130_fd_sc_hd__fill_1
XFILLER_22_15 vssd vssd vccd vccd sky130_fd_sc_hd__decap_3
X_223_ net25 regs\[3\]\[0\] _129_ vssd vssd vccd vccd _020_ sky130_fd_sc_hd__mux2_1
XTAP_TAPCELL_ROW_21_125 vssd vccd sky130_fd_sc_hd__tapvpwrvgnd_1
XFILLER_12_81 vssd vssd vccd vccd sky130_fd_sc_hd__decap_3
XFILLER_12_92 vssd vssd vccd vccd sky130_fd_sc_hd__fill_1
XFILLER_19_6 vssd vssd vccd vccd sky130_fd_sc_hd__decap_3
X_154_ net48 net44 net47 net55 vssd vssd vccd vccd _077_ sky130_fd_sc_hd__and4bb_2
XPHY_EDGE_ROW_25_Left_54 vssd vssd vccd vccd sky130_fd_sc_hd__decap_3
XFILLER_3_159 vssd vssd vccd vccd sky130_fd_sc_hd__decap_3
XFILLER_23_91 vssd vssd vccd vccd sky130_fd_sc_hd__decap_3
X_206_ _125_ net15 net51 vssd vssd vccd vccd _007_ sky130_fd_sc_hd__mux2_1
XFILLER_0_51 vssd vssd vccd vccd sky130_fd_sc_hd__decap_3
XFILLER_17_3 vssd vssd vccd vccd sky130_fd_sc_hd__decap_3
XFILLER_28_47 vssd vssd vccd vccd sky130_fd_sc_hd__decap_3
XFILLER_9_60 vssd vssd vccd vccd sky130_fd_sc_hd__decap_3
XFILLER_28_69 vssd vssd vccd vccd sky130_fd_sc_hd__decap_3
XFILLER_14_27 vssd vssd vccd vccd sky130_fd_sc_hd__fill_1
XFILLER_14_49 vssd vssd vccd vccd sky130_fd_sc_hd__decap_3
XPHY_EDGE_ROW_12_Left_41 vssd vssd vccd vccd sky130_fd_sc_hd__decap_3
XFILLER_20_81 vssd vssd vccd vccd sky130_fd_sc_hd__decap_3
XFILLER_25_15 vssd vssd vccd vccd sky130_fd_sc_hd__decap_3
XFILLER_25_48 vssd vssd vccd vccd sky130_fd_sc_hd__decap_3
XFILLER_26_147 vssd vssd vccd vccd sky130_fd_sc_hd__decap_3
XFILLER_6_50 vssd vssd vccd vccd sky130_fd_sc_hd__decap_3
XFILLER_15_92 vssd vssd vccd vccd sky130_fd_sc_hd__decap_3
XFILLER_17_125 vssd vssd vccd vccd sky130_fd_sc_hd__decap_3
XFILLER_17_169 vssd vssd vccd vccd sky130_fd_sc_hd__decap_3
XTAP_TAPCELL_ROW_27_142 vssd vccd sky130_fd_sc_hd__tapvpwrvgnd_1
XFILLER_23_106 vssd vssd vccd vccd sky130_fd_sc_hd__decap_3
XFILLER_14_139 vssd vssd vccd vccd sky130_fd_sc_hd__fill_1
X_170_ regs\[14\]\[0\] _091_ _092_ regs\[11\]\[0\] _090_ vssd vssd vccd vccd _093_
+ sky130_fd_sc_hd__a221o_1
XTAP_TAPCELL_ROW_24_134 vssd vccd sky130_fd_sc_hd__tapvpwrvgnd_1
X_299_ net39 _017_ net30 vssd vssd vccd vccd regs\[2\]\[1\] sky130_fd_sc_hd__dfrtp_1
XFILLER_0_9 vssd vssd vccd vccd sky130_fd_sc_hd__decap_3
XFILLER_22_27 vssd vssd vccd vccd sky130_fd_sc_hd__fill_1
XTAP_TAPCELL_ROW_21_126 vssd vccd sky130_fd_sc_hd__tapvpwrvgnd_1
XFILLER_10_164 vssd vssd vccd vccd sky130_fd_sc_hd__fill_1
XFILLER_6_113 vssd vssd vccd vccd sky130_fd_sc_hd__decap_3
XFILLER_6_135 vssd vssd vccd vccd sky130_fd_sc_hd__decap_3
XFILLER_8_29 vssd vssd vccd vccd sky130_fd_sc_hd__decap_3
X_222_ net50 _081_ vssd vssd vccd vccd _129_ sky130_fd_sc_hd__nand2_2
X_153_ regs\[4\]\[0\] _074_ net18 regs\[2\]\[0\] vssd vssd vccd vccd _076_ sky130_fd_sc_hd__a22o_1
XFILLER_23_70 vssd vssd vccd vccd sky130_fd_sc_hd__decap_3
XFILLER_3_116 vssd vssd vccd vccd sky130_fd_sc_hd__decap_3
X_205_ regs\[0\]\[3\] _079_ _118_ _124_ vssd vssd vccd vccd _125_ sky130_fd_sc_hd__o22a_1
XFILLER_0_41 vssd vssd vccd vccd sky130_fd_sc_hd__decap_3
XFILLER_0_63 vssd vssd vccd vccd sky130_fd_sc_hd__decap_3
XFILLER_0_85 vssd vssd vccd vccd sky130_fd_sc_hd__decap_3
XFILLER_0_119 vssd vssd vccd vccd sky130_fd_sc_hd__decap_3
XFILLER_28_15 vssd vssd vccd vccd sky130_fd_sc_hd__decap_3
XFILLER_18_81 vssd vssd vccd vccd sky130_fd_sc_hd__decap_3
XFILLER_14_17 vssd vssd vccd vccd sky130_fd_sc_hd__decap_3
XFILLER_26_159 vssd vssd vccd vccd sky130_fd_sc_hd__decap_3
XFILLER_6_73 vssd vssd vccd vccd sky130_fd_sc_hd__decap_3
XTAP_TAPCELL_ROW_27_143 vssd vccd sky130_fd_sc_hd__tapvpwrvgnd_1
XFILLER_14_107 vssd vssd vccd vccd sky130_fd_sc_hd__decap_3
XFILLER_7_3 vssd vssd vccd vccd sky130_fd_sc_hd__decap_3
XTAP_TAPCELL_ROW_24_135 vssd vccd sky130_fd_sc_hd__tapvpwrvgnd_1
X_298_ net39 _016_ net30 vssd vssd vccd vccd regs\[2\]\[0\] sky130_fd_sc_hd__dfrtp_1
XFILLER_22_39 vssd vssd vccd vccd sky130_fd_sc_hd__decap_3
XFILLER_10_132 vssd vssd vccd vccd sky130_fd_sc_hd__decap_3
XFILLER_26_9 vssd vssd vccd vccd sky130_fd_sc_hd__decap_3
X_221_ net54 regs\[2\]\[3\] _128_ vssd vssd vccd vccd _019_ sky130_fd_sc_hd__mux2_1
X_152_ net55 net44 net47 net48 vssd vssd vccd vccd _075_ sky130_fd_sc_hd__nor4b_1
XFILLER_17_39 vssd vssd vccd vccd sky130_fd_sc_hd__fill_1
XFILLER_3_128 vssd vssd vccd vccd sky130_fd_sc_hd__decap_3
X_204_ regs\[12\]\[3\] _085_ _120_ _121_ _123_ vssd vssd vccd vccd _124_ sky130_fd_sc_hd__a2111o_1
XFILLER_0_75 vssd vssd vccd vccd sky130_fd_sc_hd__decap_3
XFILLER_0_97 vssd vssd vccd vccd sky130_fd_sc_hd__decap_3
XFILLER_24_6 vssd vssd vccd vccd sky130_fd_sc_hd__decap_3
XFILLER_2_150 vssd vssd vccd vccd sky130_fd_sc_hd__decap_3
XFILLER_9_51 vssd vssd vccd vccd sky130_fd_sc_hd__decap_3
XFILLER_0_109 vssd vssd vccd vccd sky130_fd_sc_hd__decap_3
XFILLER_28_27 vssd vssd vccd vccd sky130_fd_sc_hd__fill_1
XFILLER_28_38 vssd vssd vccd vccd sky130_fd_sc_hd__decap_3
XFILLER_14_29 vssd vssd vccd vccd sky130_fd_sc_hd__decap_3
XFILLER_22_3 vssd vssd vccd vccd sky130_fd_sc_hd__decap_3
XFILLER_6_85 vssd vssd vccd vccd sky130_fd_sc_hd__decap_3
XTAP_TAPCELL_ROW_27_144 vssd vccd sky130_fd_sc_hd__tapvpwrvgnd_1
XFILLER_22_152 vssd vssd vccd vccd sky130_fd_sc_hd__fill_2
X_297_ net38 _015_ net29 vssd vssd vccd vccd regs\[1\]\[3\] sky130_fd_sc_hd__dfrtp_1
XFILLER_22_18 vssd vssd vccd vccd sky130_fd_sc_hd__decap_3
XFILLER_3_53 vssd vssd vccd vccd sky130_fd_sc_hd__decap_3
XFILLER_3_86 vssd vssd vccd vccd sky130_fd_sc_hd__decap_3
X_220_ net20 regs\[2\]\[2\] _128_ vssd vssd vccd vccd _018_ sky130_fd_sc_hd__mux2_1
X_151_ net45 net46 _073_ vssd vssd vccd vccd _074_ sky130_fd_sc_hd__and3b_2
XFILLER_19_9 vssd vssd vccd vccd sky130_fd_sc_hd__decap_3
X_349_ net36 _067_ net27 vssd vssd vccd vccd regs\[14\]\[3\] sky130_fd_sc_hd__dfrtp_1
XTAP_TAPCELL_ROW_8_85 vssd vccd sky130_fd_sc_hd__tapvpwrvgnd_1
XFILLER_0_21 vssd vssd vccd vccd sky130_fd_sc_hd__decap_3
XFILLER_0_32 vssd vssd vccd vccd sky130_fd_sc_hd__decap_3
XFILLER_0_54 vssd vssd vccd vccd sky130_fd_sc_hd__fill_2
XFILLER_17_6 vssd vssd vccd vccd sky130_fd_sc_hd__decap_3
XFILLER_23_61 vssd vssd vccd vccd sky130_fd_sc_hd__decap_3
XFILLER_23_94 vssd vssd vccd vccd sky130_fd_sc_hd__decap_3
XFILLER_2_162 vssd vssd vccd vccd sky130_fd_sc_hd__decap_3
X_203_ regs\[15\]\[3\] _068_ _084_ regs\[8\]\[3\] _122_ vssd vssd vccd vccd _123_
+ sky130_fd_sc_hd__a221o_1
XFILLER_9_63 vssd vssd vccd vccd sky130_fd_sc_hd__decap_3
XFILLER_18_72 vssd vssd vccd vccd sky130_fd_sc_hd__decap_3
XFILLER_20_40 vssd vssd vccd vccd sky130_fd_sc_hd__decap_3
XFILLER_6_53 vssd vssd vccd vccd sky130_fd_sc_hd__decap_3
XPHY_EDGE_ROW_16_Left_45 vssd vssd vccd vccd sky130_fd_sc_hd__decap_3
XFILLER_25_18 vssd vssd vccd vccd sky130_fd_sc_hd__decap_3
XFILLER_15_51 vssd vssd vccd vccd sky130_fd_sc_hd__decap_3
XFILLER_15_95 vssd vssd vccd vccd sky130_fd_sc_hd__fill_1
XFILLER_16_150 vssd vssd vccd vccd sky130_fd_sc_hd__fill_2
XFILLER_23_109 vssd vssd vccd vccd sky130_fd_sc_hd__decap_3
XFILLER_9_113 vssd vssd vccd vccd sky130_fd_sc_hd__decap_3
X_296_ net42 _014_ net33 vssd vssd vccd vccd regs\[1\]\[2\] sky130_fd_sc_hd__dfrtp_1
XFILLER_6_116 vssd vssd vccd vccd sky130_fd_sc_hd__decap_3
XFILLER_6_138 vssd vssd vccd vccd sky130_fd_sc_hd__fill_2
X_150_ net48 net55 vssd vssd vccd vccd _073_ sky130_fd_sc_hd__nor2_1
XPHY_EDGE_ROW_16_Right_16 vssd vssd vccd vccd sky130_fd_sc_hd__decap_3
X_348_ net35 _066_ net26 vssd vssd vccd vccd regs\[14\]\[2\] sky130_fd_sc_hd__dfrtp_1
X_279_ net22 regs\[14\]\[1\] _140_ vssd vssd vccd vccd _065_ sky130_fd_sc_hd__mux2_1
XTAP_TAPCELL_ROW_8_86 vssd vccd sky130_fd_sc_hd__tapvpwrvgnd_1
XPHY_EDGE_ROW_25_Right_25 vssd vssd vccd vccd sky130_fd_sc_hd__decap_3
XFILLER_0_44 vssd vssd vccd vccd sky130_fd_sc_hd__fill_1
XFILLER_23_73 vssd vssd vccd vccd sky130_fd_sc_hd__fill_2
X_202_ regs\[9\]\[3\] _089_ _091_ regs\[14\]\[3\] vssd vssd vccd vccd _122_ sky130_fd_sc_hd__a22o_1
XPHY_EDGE_ROW_4_Left_33 vssd vssd vccd vccd sky130_fd_sc_hd__decap_3
XFILLER_0_66 vssd vssd vccd vccd sky130_fd_sc_hd__decap_3
XFILLER_0_88 vssd vssd vccd vccd sky130_fd_sc_hd__decap_3
XFILLER_28_18 vssd vssd vccd vccd sky130_fd_sc_hd__decap_3
XFILLER_28_29 vssd vssd vccd vccd sky130_fd_sc_hd__decap_3
XTAP_TAPCELL_ROW_5_76 vssd vccd sky130_fd_sc_hd__tapvpwrvgnd_1
XPHY_EDGE_ROW_2_Right_2 vssd vssd vccd vccd sky130_fd_sc_hd__decap_3
XFILLER_20_52 vssd vssd vccd vccd sky130_fd_sc_hd__decap_3
XFILLER_6_76 vssd vssd vccd vccd sky130_fd_sc_hd__decap_3
XFILLER_25_140 vssd vssd vccd vccd sky130_fd_sc_hd__fill_2
XFILLER_25_162 vssd vssd vccd vccd sky130_fd_sc_hd__decap_3
XFILLER_22_132 vssd vssd vccd vccd sky130_fd_sc_hd__decap_3
XFILLER_26_51 vssd vssd vccd vccd sky130_fd_sc_hd__decap_3
XFILLER_7_6 vssd vssd vccd vccd sky130_fd_sc_hd__decap_3
XFILLER_26_95 vssd vssd vccd vccd sky130_fd_sc_hd__decap_3
XFILLER_3_66 vssd vssd vccd vccd sky130_fd_sc_hd__decap_3
XFILLER_9_103 vssd vssd vccd vccd sky130_fd_sc_hd__decap_3
X_295_ net38 _013_ net29 vssd vssd vccd vccd regs\[1\]\[1\] sky130_fd_sc_hd__dfrtp_1
XFILLER_10_102 vssd vssd vccd vccd sky130_fd_sc_hd__fill_1
XFILLER_10_135 vssd vssd vccd vccd sky130_fd_sc_hd__decap_3
XTAP_TAPCELL_ROW_12_97 vssd vccd sky130_fd_sc_hd__tapvpwrvgnd_1
XFILLER_5_3 vssd vssd vccd vccd sky130_fd_sc_hd__fill_2
X_347_ net36 _065_ net27 vssd vssd vccd vccd regs\[14\]\[1\] sky130_fd_sc_hd__dfrtp_1
X_278_ net24 regs\[14\]\[0\] _140_ vssd vssd vccd vccd _064_ sky130_fd_sc_hd__mux2_1
XTAP_TAPCELL_ROW_8_87 vssd vccd sky130_fd_sc_hd__tapvpwrvgnd_1
XFILLER_3_109 vssd vssd vccd vccd sky130_fd_sc_hd__decap_3
XFILLER_23_85 vssd vssd vccd vccd sky130_fd_sc_hd__decap_3
XFILLER_2_153 vssd vssd vccd vccd sky130_fd_sc_hd__decap_3
X_201_ regs\[10\]\[3\] _086_ _092_ regs\[11\]\[3\] vssd vssd vccd vccd _121_ sky130_fd_sc_hd__a22o_1
XFILLER_0_12 vssd vssd vccd vccd sky130_fd_sc_hd__decap_3
XFILLER_0_78 vssd vssd vccd vccd sky130_fd_sc_hd__decap_3
XFILLER_24_9 vssd vssd vccd vccd sky130_fd_sc_hd__decap_3
XFILLER_9_54 vssd vssd vccd vccd sky130_fd_sc_hd__fill_2
XFILLER_18_41 vssd vssd vccd vccd sky130_fd_sc_hd__decap_3
XFILLER_22_6 vssd vssd vccd vccd sky130_fd_sc_hd__decap_3
XTAP_TAPCELL_ROW_5_77 vssd vccd sky130_fd_sc_hd__tapvpwrvgnd_1
XFILLER_19_160 vssd vssd vccd vccd sky130_fd_sc_hd__decap_3
XFILLER_20_3 vssd vssd vccd vccd sky130_fd_sc_hd__decap_3
XFILLER_6_88 vssd vssd vccd vccd sky130_fd_sc_hd__fill_2
XTAP_TAPCELL_ROW_2_67 vssd vccd sky130_fd_sc_hd__tapvpwrvgnd_1
.ends
