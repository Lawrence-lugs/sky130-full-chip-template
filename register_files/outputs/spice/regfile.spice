* NGSPICE file created from regfile.ext - technology: sky130A

* Black-box entry subcircuit for sky130_fd_sc_hd__fill_2 abstract view
.subckt sky130_fd_sc_hd__fill_2 VGND VNB VPB VPWR
.ends

* Black-box entry subcircuit for sky130_fd_sc_hd__decap_3 abstract view
.subckt sky130_fd_sc_hd__decap_3 VGND VNB VPB VPWR
.ends

* Black-box entry subcircuit for sky130_fd_sc_hd__tapvpwrvgnd_1 abstract view
.subckt sky130_fd_sc_hd__tapvpwrvgnd_1 VGND VPWR
.ends

* Black-box entry subcircuit for sky130_fd_sc_hd__fill_1 abstract view
.subckt sky130_fd_sc_hd__fill_1 VGND VNB VPB VPWR
.ends

* Black-box entry subcircuit for sky130_fd_sc_hd__dfrtp_1 abstract view
.subckt sky130_fd_sc_hd__dfrtp_1 CLK D RESET_B VGND VNB VPB VPWR Q
.ends

* Black-box entry subcircuit for sky130_fd_sc_hd__mux2_1 abstract view
.subckt sky130_fd_sc_hd__mux2_1 A0 A1 S VGND VNB VPB VPWR X
.ends

* Black-box entry subcircuit for sky130_fd_sc_hd__dlymetal6s2s_1 abstract view
.subckt sky130_fd_sc_hd__dlymetal6s2s_1 A VGND VNB VPB VPWR X
.ends

* Black-box entry subcircuit for sky130_fd_sc_hd__buf_2 abstract view
.subckt sky130_fd_sc_hd__buf_2 A VGND VNB VPB VPWR X
.ends

* Black-box entry subcircuit for sky130_fd_sc_hd__a32o_1 abstract view
.subckt sky130_fd_sc_hd__a32o_1 A1 A2 A3 B1 B2 VGND VNB VPB VPWR X
.ends

* Black-box entry subcircuit for sky130_fd_sc_hd__a221o_1 abstract view
.subckt sky130_fd_sc_hd__a221o_1 A1 A2 B1 B2 C1 VGND VNB VPB VPWR X
.ends

* Black-box entry subcircuit for sky130_fd_sc_hd__and3_1 abstract view
.subckt sky130_fd_sc_hd__and3_1 A B C VGND VNB VPB VPWR X
.ends

* Black-box entry subcircuit for sky130_fd_sc_hd__o21ba_1 abstract view
.subckt sky130_fd_sc_hd__o21ba_1 A1 A2 B1_N VGND VNB VPB VPWR X
.ends

* Black-box entry subcircuit for sky130_fd_sc_hd__a2111o_1 abstract view
.subckt sky130_fd_sc_hd__a2111o_1 A1 A2 B1 C1 D1 VGND VNB VPB VPWR X
.ends

* Black-box entry subcircuit for sky130_fd_sc_hd__and4b_2 abstract view
.subckt sky130_fd_sc_hd__and4b_2 A_N B C D VGND VNB VPB VPWR X
.ends

* Black-box entry subcircuit for sky130_fd_sc_hd__diode_2 abstract view
.subckt sky130_fd_sc_hd__diode_2 DIODE VGND VNB VPB VPWR
.ends

* Black-box entry subcircuit for sky130_fd_sc_hd__or4_1 abstract view
.subckt sky130_fd_sc_hd__or4_1 A B C D VGND VNB VPB VPWR X
.ends

* Black-box entry subcircuit for sky130_fd_sc_hd__and2_4 abstract view
.subckt sky130_fd_sc_hd__and2_4 A B VGND VNB VPB VPWR X
.ends

* Black-box entry subcircuit for sky130_fd_sc_hd__clkbuf_2 abstract view
.subckt sky130_fd_sc_hd__clkbuf_2 A VGND VNB VPB VPWR X
.ends

* Black-box entry subcircuit for sky130_fd_sc_hd__and3b_1 abstract view
.subckt sky130_fd_sc_hd__and3b_1 A_N B C VGND VNB VPB VPWR X
.ends

* Black-box entry subcircuit for sky130_fd_sc_hd__and3_4 abstract view
.subckt sky130_fd_sc_hd__and3_4 A B C VGND VNB VPB VPWR X
.ends

* Black-box entry subcircuit for sky130_fd_sc_hd__or3_1 abstract view
.subckt sky130_fd_sc_hd__or3_1 A B C VGND VNB VPB VPWR X
.ends

* Black-box entry subcircuit for sky130_fd_sc_hd__a22o_1 abstract view
.subckt sky130_fd_sc_hd__a22o_1 A1 A2 B1 B2 VGND VNB VPB VPWR X
.ends

* Black-box entry subcircuit for sky130_fd_sc_hd__and2b_2 abstract view
.subckt sky130_fd_sc_hd__and2b_2 A_N B VGND VNB VPB VPWR X
.ends

* Black-box entry subcircuit for sky130_fd_sc_hd__a21o_1 abstract view
.subckt sky130_fd_sc_hd__a21o_1 A1 A2 B1 VGND VNB VPB VPWR X
.ends

* Black-box entry subcircuit for sky130_fd_sc_hd__and4bb_2 abstract view
.subckt sky130_fd_sc_hd__and4bb_2 A_N B_N C D VGND VNB VPB VPWR X
.ends

* Black-box entry subcircuit for sky130_fd_sc_hd__and2b_4 abstract view
.subckt sky130_fd_sc_hd__and2b_4 A_N B VGND VNB VPB VPWR X
.ends

* Black-box entry subcircuit for sky130_fd_sc_hd__nor4b_2 abstract view
.subckt sky130_fd_sc_hd__nor4b_2 A B C D_N VGND VNB VPB VPWR Y
.ends

* Black-box entry subcircuit for sky130_fd_sc_hd__a31o_1 abstract view
.subckt sky130_fd_sc_hd__a31o_1 A1 A2 A3 B1 VGND VNB VPB VPWR X
.ends

* Black-box entry subcircuit for sky130_fd_sc_hd__clkbuf_4 abstract view
.subckt sky130_fd_sc_hd__clkbuf_4 A VGND VNB VPB VPWR X
.ends

* Black-box entry subcircuit for sky130_fd_sc_hd__nand2_4 abstract view
.subckt sky130_fd_sc_hd__nand2_4 A B VGND VNB VPB VPWR Y
.ends

* Black-box entry subcircuit for sky130_fd_sc_hd__and3_2 abstract view
.subckt sky130_fd_sc_hd__and3_2 A B C VGND VNB VPB VPWR X
.ends

* Black-box entry subcircuit for sky130_fd_sc_hd__and4_1 abstract view
.subckt sky130_fd_sc_hd__and4_1 A B C D VGND VNB VPB VPWR X
.ends

* Black-box entry subcircuit for sky130_fd_sc_hd__and2_2 abstract view
.subckt sky130_fd_sc_hd__and2_2 A B VGND VNB VPB VPWR X
.ends

* Black-box entry subcircuit for sky130_fd_sc_hd__buf_1 abstract view
.subckt sky130_fd_sc_hd__buf_1 A VGND VNB VPB VPWR X
.ends

* Black-box entry subcircuit for sky130_fd_sc_hd__nor4b_1 abstract view
.subckt sky130_fd_sc_hd__nor4b_1 A B C D_N VGND VNB VPB VPWR Y
.ends

* Black-box entry subcircuit for sky130_fd_sc_hd__and2_1 abstract view
.subckt sky130_fd_sc_hd__and2_1 A B VGND VNB VPB VPWR X
.ends

* Black-box entry subcircuit for sky130_fd_sc_hd__clkbuf_1 abstract view
.subckt sky130_fd_sc_hd__clkbuf_1 A VGND VNB VPB VPWR X
.ends

* Black-box entry subcircuit for sky130_fd_sc_hd__and4bb_1 abstract view
.subckt sky130_fd_sc_hd__and4bb_1 A_N B_N C D VGND VNB VPB VPWR X
.ends

* Black-box entry subcircuit for sky130_fd_sc_hd__and2b_1 abstract view
.subckt sky130_fd_sc_hd__and2b_1 A_N B VGND VNB VPB VPWR X
.ends

* Black-box entry subcircuit for sky130_fd_sc_hd__nand2b_2 abstract view
.subckt sky130_fd_sc_hd__nand2b_2 A_N B VGND VNB VPB VPWR Y
.ends

* Black-box entry subcircuit for sky130_fd_sc_hd__nor4_1 abstract view
.subckt sky130_fd_sc_hd__nor4_1 A B C D VGND VNB VPB VPWR Y
.ends

* Black-box entry subcircuit for sky130_fd_sc_hd__a211o_1 abstract view
.subckt sky130_fd_sc_hd__a211o_1 A1 A2 B1 C1 VGND VNB VPB VPWR X
.ends

* Black-box entry subcircuit for sky130_fd_sc_hd__buf_4 abstract view
.subckt sky130_fd_sc_hd__buf_4 A VGND VNB VPB VPWR X
.ends

.subckt regfile VDD VSS addr[0] addr[1] addr[2] addr[3] addr[4] clk nrst rdata[0]
+ rdata[1] rdata[2] rdata[3] rdata[4] rdata[5] rdata[6] rdata[7] wdata[0] wdata[1]
+ wdata[2] wdata[3] wdata[4] wdata[5] wdata[6] wdata[7] we
XFILLER_39_266 VSS VSS VDD VDD sky130_fd_sc_hd__fill_2
XFILLER_54_203 VSS VSS VDD VDD sky130_fd_sc_hd__decap_3
XFILLER_10_306 VSS VSS VDD VDD sky130_fd_sc_hd__fill_2
XFILLER_22_144 VSS VSS VDD VDD sky130_fd_sc_hd__decap_3
XFILLER_52_29 VSS VSS VDD VDD sky130_fd_sc_hd__decap_3
XTAP_TAPCELL_ROW_52_437 VSS VDD sky130_fd_sc_hd__tapvpwrvgnd_1
XFILLER_26_85 VSS VSS VDD VDD sky130_fd_sc_hd__decap_3
XFILLER_45_225 VSS VSS VDD VDD sky130_fd_sc_hd__fill_2
XFILLER_13_166 VSS VSS VDD VDD sky130_fd_sc_hd__fill_2
XFILLER_5_321 VSS VSS VDD VDD sky130_fd_sc_hd__fill_2
XFILLER_3_12 VSS VSS VDD VDD sky130_fd_sc_hd__decap_3
XFILLER_3_45 VSS VSS VDD VDD sky130_fd_sc_hd__decap_3
XFILLER_5_343 VSS VSS VDD VDD sky130_fd_sc_hd__fill_1
XTAP_TAPCELL_ROW_8_170 VSS VDD sky130_fd_sc_hd__tapvpwrvgnd_1
XFILLER_36_203 VSS VSS VDD VDD sky130_fd_sc_hd__decap_3
X_1270_ net100 _0124_ net65 VSS VSS VDD VDD regs\[13\]\[4\] sky130_fd_sc_hd__dfrtp_1
X_0985_ regs\[13\]\[0\] net43 _0567_ VSS VSS VDD VDD _0120_ sky130_fd_sc_hd__mux2_1
XFILLER_47_18 VSS VSS VDD VDD sky130_fd_sc_hd__decap_3
X_1399_ net86 _0253_ net51 VSS VSS VDD VDD regs\[29\]\[5\] sky130_fd_sc_hd__dfrtp_1
Xfanout105 net106 VSS VSS VDD VDD net105 sky130_fd_sc_hd__dlymetal6s2s_1
Xfanout116 net6 VSS VSS VDD VDD net116 sky130_fd_sc_hd__buf_2
Xfanout127 net138 VSS VSS VDD VDD net127 sky130_fd_sc_hd__buf_2
Xfanout138 net5 VSS VSS VDD VDD net138 sky130_fd_sc_hd__buf_2
Xfanout149 net16 VSS VSS VDD VDD net149 sky130_fd_sc_hd__buf_2
XFILLER_27_225 VSS VSS VDD VDD sky130_fd_sc_hd__decap_3
XFILLER_27_258 VSS VSS VDD VDD sky130_fd_sc_hd__fill_2
XFILLER_10_169 VSS VSS VDD VDD sky130_fd_sc_hd__decap_3
XFILLER_12_21 VSS VSS VDD VDD sky130_fd_sc_hd__decap_3
XFILLER_12_32 VSS VSS VDD VDD sky130_fd_sc_hd__decap_3
XFILLER_37_51 VSS VSS VDD VDD sky130_fd_sc_hd__decap_3
XFILLER_33_228 VSS VSS VDD VDD sky130_fd_sc_hd__decap_3
XFILLER_53_72 VSS VSS VDD VDD sky130_fd_sc_hd__decap_3
X_0770_ net127 regs\[24\]\[4\] net25 _0333_ regs\[23\]\[4\] VSS VSS VDD VDD _0461_
+ sky130_fd_sc_hd__a32o_1
XFILLER_56_309 VSS VSS VDD VDD sky130_fd_sc_hd__decap_3
X_1253_ net84 _0107_ net49 VSS VSS VDD VDD regs\[11\]\[3\] sky130_fd_sc_hd__dfrtp_1
X_1322_ net89 _0176_ net54 VSS VSS VDD VDD regs\[20\]\[0\] sky130_fd_sc_hd__dfrtp_1
X_1184_ net82 _0038_ net47 VSS VSS VDD VDD regs\[2\]\[6\] sky130_fd_sc_hd__dfrtp_1
XFILLER_32_294 VSS VSS VDD VDD sky130_fd_sc_hd__decap_3
X_0968_ regs\[11\]\[1\] net41 _0565_ VSS VSS VDD VDD _0105_ sky130_fd_sc_hd__mux2_1
X_0899_ regs\[3\]\[4\] net164 _0557_ VSS VSS VDD VDD _0044_ sky130_fd_sc_hd__mux2_1
XFILLER_38_309 VSS VSS VDD VDD sky130_fd_sc_hd__fill_2
XFILLER_48_50 VSS VSS VDD VDD sky130_fd_sc_hd__decap_3
XFILLER_0_24 VSS VSS VDD VDD sky130_fd_sc_hd__decap_3
XFILLER_0_35 VSS VSS VDD VDD sky130_fd_sc_hd__decap_3
XFILLER_0_57 VSS VSS VDD VDD sky130_fd_sc_hd__decap_3
XFILLER_17_9 VSS VSS VDD VDD sky130_fd_sc_hd__decap_3
XFILLER_48_83 VSS VSS VDD VDD sky130_fd_sc_hd__fill_1
XFILLER_48_94 VSS VSS VDD VDD sky130_fd_sc_hd__decap_3
XTAP_TAPCELL_ROW_16_223 VSS VDD sky130_fd_sc_hd__tapvpwrvgnd_1
X_0822_ net123 regs\[27\]\[6\] net31 _0299_ regs\[1\]\[6\] VSS VSS VDD VDD _0511_
+ sky130_fd_sc_hd__a32o_1
XFILLER_9_33 VSS VSS VDD VDD sky130_fd_sc_hd__decap_3
XFILLER_50_3 VSS VSS VDD VDD sky130_fd_sc_hd__decap_3
X_0753_ regs\[20\]\[4\] _0320_ _0336_ regs\[2\]\[4\] _0443_ VSS VSS VDD VDD _0444_
+ sky130_fd_sc_hd__a221o_1
X_0684_ net133 regs\[27\]\[2\] _0306_ VSS VSS VDD VDD _0377_ sky130_fd_sc_hd__and3_1
XFILLER_56_106 VSS VSS VDD VDD sky130_fd_sc_hd__decap_3
XFILLER_56_139 VSS VSS VDD VDD sky130_fd_sc_hd__fill_1
X_1236_ net87 _0090_ net52 VSS VSS VDD VDD regs\[9\]\[2\] sky130_fd_sc_hd__dfrtp_1
X_1305_ net102 _0159_ net67 VSS VSS VDD VDD regs\[17\]\[7\] sky130_fd_sc_hd__dfrtp_1
XTAP_TAPCELL_ROW_39_359 VSS VDD sky130_fd_sc_hd__tapvpwrvgnd_1
XFILLER_52_323 VSS VSS VDD VDD sky130_fd_sc_hd__decap_3
X_1167_ net93 _0021_ net58 VSS VSS VDD VDD regs\[0\]\[5\] sky130_fd_sc_hd__dfrtp_1
X_1098_ regs\[25\]\[5\] net161 _0270_ VSS VSS VDD VDD _0221_ sky130_fd_sc_hd__mux2_1
XFILLER_20_253 VSS VSS VDD VDD sky130_fd_sc_hd__decap_3
XTAP_TAPCELL_ROW_22_259 VSS VDD sky130_fd_sc_hd__tapvpwrvgnd_1
XFILLER_18_53 VSS VSS VDD VDD sky130_fd_sc_hd__decap_3
XFILLER_11_231 VSS VSS VDD VDD sky130_fd_sc_hd__decap_3
XFILLER_34_85 VSS VSS VDD VDD sky130_fd_sc_hd__fill_1
XTAP_TAPCELL_ROW_13_204 VSS VDD sky130_fd_sc_hd__tapvpwrvgnd_1
XFILLER_50_62 VSS VSS VDD VDD sky130_fd_sc_hd__decap_3
XFILLER_7_279 VSS VSS VDD VDD sky130_fd_sc_hd__fill_1
XFILLER_15_6 VSS VSS VDD VDD sky130_fd_sc_hd__decap_3
XFILLER_38_106 VSS VSS VDD VDD sky130_fd_sc_hd__decap_3
XFILLER_46_150 VSS VSS VDD VDD sky130_fd_sc_hd__decap_3
X_1021_ regs\[17\]\[0\] net44 _0571_ VSS VSS VDD VDD _0152_ sky130_fd_sc_hd__mux2_1
X_0805_ regs\[0\]\[5\] _0327_ net145 VSS VSS VDD VDD _0495_ sky130_fd_sc_hd__o21ba_1
X_0736_ net129 regs\[23\]\[3\] _0303_ VSS VSS VDD VDD _0428_ sky130_fd_sc_hd__and3_1
X_0667_ regs\[12\]\[1\] _0335_ _0358_ _0359_ _0360_ VSS VSS VDD VDD _0361_ sky130_fd_sc_hd__a2111o_1
X_0598_ net176 net142 net140 net144 VSS VSS VDD VDD _0293_ sky130_fd_sc_hd__and4b_2
XFILLER_25_334 VSS VSS VDD VDD sky130_fd_sc_hd__fill_2
XFILLER_37_183 VSS VSS VDD VDD sky130_fd_sc_hd__decap_3
XFILLER_55_18 VSS VSS VDD VDD sky130_fd_sc_hd__decap_3
X_1219_ net92 _0073_ net57 VSS VSS VDD VDD regs\[7\]\[1\] sky130_fd_sc_hd__dfrtp_1
XFILLER_52_197 VSS VSS VDD VDD sky130_fd_sc_hd__fill_2
XFILLER_20_21 VSS VSS VDD VDD sky130_fd_sc_hd__decap_3
XFILLER_20_98 VSS VSS VDD VDD sky130_fd_sc_hd__decap_3
XFILLER_29_30 VSS VSS VDD VDD sky130_fd_sc_hd__decap_3
XFILLER_29_52 VSS VSS VDD VDD sky130_fd_sc_hd__decap_3
XFILLER_29_63 VSS VSS VDD VDD sky130_fd_sc_hd__decap_3
XFILLER_45_51 VSS VSS VDD VDD sky130_fd_sc_hd__decap_3
XFILLER_45_95 VSS VSS VDD VDD sky130_fd_sc_hd__decap_3
XFILLER_43_197 VSS VSS VDD VDD sky130_fd_sc_hd__decap_3
XFILLER_6_12 VSS VSS VDD VDD sky130_fd_sc_hd__decap_3
XANTENNA_5 net12 VSS VSS VDD VDD sky130_fd_sc_hd__diode_2
XFILLER_3_260 VSS VSS VDD VDD sky130_fd_sc_hd__fill_1
XFILLER_6_56 VSS VSS VDD VDD sky130_fd_sc_hd__decap_3
XFILLER_13_3 VSS VSS VDD VDD sky130_fd_sc_hd__decap_3
XTAP_TAPCELL_ROW_49_421 VSS VDD sky130_fd_sc_hd__tapvpwrvgnd_1
XFILLER_34_153 VSS VSS VDD VDD sky130_fd_sc_hd__decap_3
X_1004_ regs\[15\]\[1\] net40 _0569_ VSS VSS VDD VDD _0137_ sky130_fd_sc_hd__mux2_1
XFILLER_57_212 VSS VSS VDD VDD sky130_fd_sc_hd__decap_3
XFILLER_57_234 VSS VSS VDD VDD sky130_fd_sc_hd__decap_3
X_0719_ _0407_ _0408_ _0409_ _0410_ VSS VSS VDD VDD _0411_ sky130_fd_sc_hd__or4_1
XFILLER_15_21 VSS VSS VDD VDD sky130_fd_sc_hd__decap_3
XFILLER_17_109 VSS VSS VDD VDD sky130_fd_sc_hd__decap_3
XFILLER_25_164 VSS VSS VDD VDD sky130_fd_sc_hd__decap_3
XFILLER_57_256 VSS VSS VDD VDD sky130_fd_sc_hd__decap_3
XTAP_TAPCELL_ROW_55_457 VSS VDD sky130_fd_sc_hd__tapvpwrvgnd_1
XFILLER_13_337 VSS VSS VDD VDD sky130_fd_sc_hd__decap_3
XFILLER_15_54 VSS VSS VDD VDD sky130_fd_sc_hd__fill_2
XFILLER_25_197 VSS VSS VDD VDD sky130_fd_sc_hd__decap_3
XFILLER_31_53 VSS VSS VDD VDD sky130_fd_sc_hd__decap_3
Xoutput20 net20 VSS VSS VDD VDD rdata[3] sky130_fd_sc_hd__buf_2
XFILLER_0_296 VSS VSS VDD VDD sky130_fd_sc_hd__decap_3
XFILLER_48_289 VSS VSS VDD VDD sky130_fd_sc_hd__fill_1
XFILLER_56_50 VSS VSS VDD VDD sky130_fd_sc_hd__decap_3
XFILLER_56_83 VSS VSS VDD VDD sky130_fd_sc_hd__fill_1
XTAP_TAPCELL_ROW_46_402 VSS VDD sky130_fd_sc_hd__tapvpwrvgnd_1
XFILLER_56_94 VSS VSS VDD VDD sky130_fd_sc_hd__decap_3
XFILLER_39_212 VSS VSS VDD VDD sky130_fd_sc_hd__decap_3
XFILLER_39_245 VSS VSS VDD VDD sky130_fd_sc_hd__decap_3
XFILLER_39_278 VSS VSS VDD VDD sky130_fd_sc_hd__fill_2
XFILLER_54_215 VSS VSS VDD VDD sky130_fd_sc_hd__fill_1
XFILLER_54_237 VSS VSS VDD VDD sky130_fd_sc_hd__decap_3
XFILLER_52_19 VSS VSS VDD VDD sky130_fd_sc_hd__decap_3
XTAP_TAPCELL_ROW_52_438 VSS VDD sky130_fd_sc_hd__tapvpwrvgnd_1
XFILLER_45_259 VSS VSS VDD VDD sky130_fd_sc_hd__decap_3
XFILLER_42_41 VSS VSS VDD VDD sky130_fd_sc_hd__fill_2
XFILLER_42_63 VSS VSS VDD VDD sky130_fd_sc_hd__decap_3
XFILLER_9_149 VSS VSS VDD VDD sky130_fd_sc_hd__fill_1
XFILLER_3_24 VSS VSS VDD VDD sky130_fd_sc_hd__decap_3
XFILLER_3_57 VSS VSS VDD VDD sky130_fd_sc_hd__decap_3
XFILLER_47_9 VSS VSS VDD VDD sky130_fd_sc_hd__decap_3
XTAP_TAPCELL_ROW_8_171 VSS VDD sky130_fd_sc_hd__tapvpwrvgnd_1
XFILLER_36_215 VSS VSS VDD VDD sky130_fd_sc_hd__decap_3
X_0984_ net149 _0313_ VSS VSS VDD VDD _0567_ sky130_fd_sc_hd__and2_4
X_1398_ net83 _0252_ net48 VSS VSS VDD VDD regs\[29\]\[4\] sky130_fd_sc_hd__dfrtp_1
Xfanout106 net107 VSS VSS VDD VDD net106 sky130_fd_sc_hd__clkbuf_2
Xfanout117 net120 VSS VSS VDD VDD net117 sky130_fd_sc_hd__clkbuf_2
Xfanout128 net130 VSS VSS VDD VDD net128 sky130_fd_sc_hd__clkbuf_2
Xfanout139 net4 VSS VSS VDD VDD net139 sky130_fd_sc_hd__clkbuf_2
XFILLER_35_281 VSS VSS VDD VDD sky130_fd_sc_hd__decap_3
XFILLER_42_207 VSS VSS VDD VDD sky130_fd_sc_hd__decap_3
XFILLER_10_115 VSS VSS VDD VDD sky130_fd_sc_hd__decap_3
XFILLER_10_137 VSS VSS VDD VDD sky130_fd_sc_hd__decap_3
XFILLER_10_148 VSS VSS VDD VDD sky130_fd_sc_hd__decap_3
XFILLER_12_88 VSS VSS VDD VDD sky130_fd_sc_hd__decap_3
XFILLER_18_215 VSS VSS VDD VDD sky130_fd_sc_hd__decap_3
XFILLER_37_30 VSS VSS VDD VDD sky130_fd_sc_hd__decap_3
XTAP_TAPCELL_ROW_5_152 VSS VDD sky130_fd_sc_hd__tapvpwrvgnd_1
XFILLER_53_51 VSS VSS VDD VDD sky130_fd_sc_hd__decap_3
XFILLER_53_84 VSS VSS VDD VDD sky130_fd_sc_hd__decap_3
XFILLER_45_6 VSS VSS VDD VDD sky130_fd_sc_hd__decap_3
XFILLER_52_7 VSS VSS VDD VDD sky130_fd_sc_hd__decap_3
X_1252_ net96 _0106_ net61 VSS VSS VDD VDD regs\[11\]\[2\] sky130_fd_sc_hd__dfrtp_1
X_1321_ net95 _0175_ net60 VSS VSS VDD VDD regs\[19\]\[7\] sky130_fd_sc_hd__dfrtp_1
XFILLER_17_281 VSS VSS VDD VDD sky130_fd_sc_hd__decap_3
XFILLER_24_229 VSS VSS VDD VDD sky130_fd_sc_hd__decap_3
XFILLER_32_240 VSS VSS VDD VDD sky130_fd_sc_hd__decap_3
X_1183_ net91 _0037_ net56 VSS VSS VDD VDD regs\[2\]\[5\] sky130_fd_sc_hd__dfrtp_1
X_0967_ regs\[11\]\[0\] net46 _0565_ VSS VSS VDD VDD _0104_ sky130_fd_sc_hd__mux2_1
X_0898_ regs\[3\]\[3\] net168 _0557_ VSS VSS VDD VDD _0043_ sky130_fd_sc_hd__mux2_1
XPHY_EDGE_ROW_12_Right_12 VSS VSS VDD VDD sky130_fd_sc_hd__decap_3
XFILLER_55_321 VSS VSS VDD VDD sky130_fd_sc_hd__decap_3
XFILLER_55_343 VSS VSS VDD VDD sky130_fd_sc_hd__fill_1
XPHY_EDGE_ROW_21_Right_21 VSS VSS VDD VDD sky130_fd_sc_hd__decap_3
XFILLER_23_21 VSS VSS VDD VDD sky130_fd_sc_hd__decap_3
XFILLER_2_100 VSS VSS VDD VDD sky130_fd_sc_hd__decap_3
XPHY_EDGE_ROW_30_Right_30 VSS VSS VDD VDD sky130_fd_sc_hd__decap_3
XFILLER_48_62 VSS VSS VDD VDD sky130_fd_sc_hd__decap_3
XFILLER_0_47 VSS VSS VDD VDD sky130_fd_sc_hd__decap_3
XFILLER_0_69 VSS VSS VDD VDD sky130_fd_sc_hd__decap_3
XFILLER_46_321 VSS VSS VDD VDD sky130_fd_sc_hd__decap_3
XFILLER_9_12 VSS VSS VDD VDD sky130_fd_sc_hd__decap_3
XFILLER_14_251 VSS VSS VDD VDD sky130_fd_sc_hd__fill_1
X_0821_ _0499_ _0503_ _0505_ _0509_ VSS VSS VDD VDD _0510_ sky130_fd_sc_hd__or4_1
X_0752_ net132 regs\[21\]\[4\] _0290_ VSS VSS VDD VDD _0443_ sky130_fd_sc_hd__and3_1
XFILLER_9_45 VSS VSS VDD VDD sky130_fd_sc_hd__decap_3
XFILLER_43_3 VSS VSS VDD VDD sky130_fd_sc_hd__decap_3
X_0683_ net133 regs\[6\]\[2\] _0296_ VSS VSS VDD VDD _0376_ sky130_fd_sc_hd__and3b_1
XFILLER_56_118 VSS VSS VDD VDD sky130_fd_sc_hd__decap_3
X_1235_ net87 _0089_ net52 VSS VSS VDD VDD regs\[9\]\[1\] sky130_fd_sc_hd__dfrtp_1
X_1304_ net102 _0158_ net67 VSS VSS VDD VDD regs\[17\]\[6\] sky130_fd_sc_hd__dfrtp_1
X_1166_ net93 _0020_ net58 VSS VSS VDD VDD regs\[0\]\[4\] sky130_fd_sc_hd__dfrtp_1
XFILLER_52_335 VSS VSS VDD VDD sky130_fd_sc_hd__decap_3
X_1097_ regs\[25\]\[4\] net164 _0270_ VSS VSS VDD VDD _0220_ sky130_fd_sc_hd__mux2_1
XFILLER_20_243 VSS VSS VDD VDD sky130_fd_sc_hd__decap_3
XFILLER_20_265 VSS VSS VDD VDD sky130_fd_sc_hd__decap_3
XFILLER_20_287 VSS VSS VDD VDD sky130_fd_sc_hd__decap_3
XFILLER_18_21 VSS VSS VDD VDD sky130_fd_sc_hd__decap_3
XFILLER_18_32 VSS VSS VDD VDD sky130_fd_sc_hd__decap_3
XFILLER_18_65 VSS VSS VDD VDD sky130_fd_sc_hd__decap_3
XFILLER_11_276 VSS VSS VDD VDD sky130_fd_sc_hd__decap_3
XFILLER_34_75 VSS VSS VDD VDD sky130_fd_sc_hd__decap_3
XFILLER_50_41 VSS VSS VDD VDD sky130_fd_sc_hd__decap_3
XFILLER_7_225 VSS VSS VDD VDD sky130_fd_sc_hd__decap_3
XTAP_TAPCELL_ROW_13_205 VSS VDD sky130_fd_sc_hd__tapvpwrvgnd_1
XFILLER_50_74 VSS VSS VDD VDD sky130_fd_sc_hd__decap_3
XFILLER_19_310 VSS VSS VDD VDD sky130_fd_sc_hd__fill_2
X_1020_ net127 net149 net37 VSS VSS VDD VDD _0571_ sky130_fd_sc_hd__and3_4
XPHY_EDGE_ROW_28_Left_86 VSS VSS VDD VDD sky130_fd_sc_hd__decap_3
X_0804_ _0470_ _0477_ _0493_ VSS VSS VDD VDD _0494_ sky130_fd_sc_hd__or3_1
X_0735_ regs\[19\]\[3\] _0324_ _0424_ _0425_ _0426_ VSS VSS VDD VDD _0427_ sky130_fd_sc_hd__a2111o_1
XFILLER_6_291 VSS VSS VDD VDD sky130_fd_sc_hd__fill_2
X_0666_ net133 regs\[22\]\[1\] net32 VSS VSS VDD VDD _0360_ sky130_fd_sc_hd__and3_1
X_0597_ net131 regs\[5\]\[0\] _0290_ VSS VSS VDD VDD _0292_ sky130_fd_sc_hd__and3b_1
XFILLER_1_90 VSS VSS VDD VDD sky130_fd_sc_hd__decap_3
XFILLER_25_324 VSS VSS VDD VDD sky130_fd_sc_hd__fill_1
XFILLER_37_140 VSS VSS VDD VDD sky130_fd_sc_hd__fill_2
X_1218_ net83 _0072_ net48 VSS VSS VDD VDD regs\[7\]\[0\] sky130_fd_sc_hd__dfrtp_1
X_1149_ net104 _0003_ net69 VSS VSS VDD VDD regs\[31\]\[3\] sky130_fd_sc_hd__dfrtp_1
XFILLER_40_338 VSS VSS VDD VDD sky130_fd_sc_hd__decap_3
XFILLER_4_217 VSS VSS VDD VDD sky130_fd_sc_hd__decap_3
XFILLER_29_42 VSS VSS VDD VDD sky130_fd_sc_hd__fill_1
XFILLER_29_75 VSS VSS VDD VDD sky130_fd_sc_hd__decap_3
XFILLER_16_302 VSS VSS VDD VDD sky130_fd_sc_hd__decap_3
XFILLER_31_305 VSS VSS VDD VDD sky130_fd_sc_hd__decap_3
XFILLER_45_30 VSS VSS VDD VDD sky130_fd_sc_hd__decap_3
XFILLER_45_63 VSS VSS VDD VDD sky130_fd_sc_hd__decap_3
XANTENNA_6 net16 VSS VSS VDD VDD sky130_fd_sc_hd__diode_2
XFILLER_6_24 VSS VSS VDD VDD sky130_fd_sc_hd__decap_3
XFILLER_6_35 VSS VSS VDD VDD sky130_fd_sc_hd__decap_3
XFILLER_19_184 VSS VSS VDD VDD sky130_fd_sc_hd__decap_3
XFILLER_34_121 VSS VSS VDD VDD sky130_fd_sc_hd__decap_3
X_1003_ regs\[15\]\[0\] net44 _0569_ VSS VSS VDD VDD _0136_ sky130_fd_sc_hd__mux2_1
XFILLER_22_338 VSS VSS VDD VDD sky130_fd_sc_hd__decap_3
XFILLER_34_165 VSS VSS VDD VDD sky130_fd_sc_hd__decap_3
XFILLER_34_187 VSS VSS VDD VDD sky130_fd_sc_hd__decap_3
X_0718_ net124 regs\[16\]\[3\] net26 _0338_ regs\[10\]\[3\] VSS VSS VDD VDD _0410_
+ sky130_fd_sc_hd__a32o_1
XPHY_EDGE_ROW_6_Right_6 VSS VSS VDD VDD sky130_fd_sc_hd__decap_3
XFILLER_57_246 VSS VSS VDD VDD sky130_fd_sc_hd__decap_3
XFILLER_57_268 VSS VSS VDD VDD sky130_fd_sc_hd__decap_3
X_0649_ _0334_ _0337_ _0339_ _0343_ VSS VSS VDD VDD _0344_ sky130_fd_sc_hd__or4_1
XFILLER_15_33 VSS VSS VDD VDD sky130_fd_sc_hd__decap_3
XFILLER_40_124 VSS VSS VDD VDD sky130_fd_sc_hd__decap_3
XFILLER_57_279 VSS VSS VDD VDD sky130_fd_sc_hd__fill_1
XFILLER_31_21 VSS VSS VDD VDD sky130_fd_sc_hd__decap_3
XFILLER_0_231 VSS VSS VDD VDD sky130_fd_sc_hd__decap_3
XFILLER_0_253 VSS VSS VDD VDD sky130_fd_sc_hd__decap_3
Xoutput21 net21 VSS VSS VDD VDD rdata[4] sky130_fd_sc_hd__buf_2
XFILLER_0_275 VSS VSS VDD VDD sky130_fd_sc_hd__decap_3
XFILLER_48_268 VSS VSS VDD VDD sky130_fd_sc_hd__decap_3
XFILLER_56_62 VSS VSS VDD VDD sky130_fd_sc_hd__decap_3
XTAP_TAPCELL_ROW_46_403 VSS VDD sky130_fd_sc_hd__tapvpwrvgnd_1
XFILLER_31_102 VSS VSS VDD VDD sky130_fd_sc_hd__decap_3
XFILLER_8_320 VSS VSS VDD VDD sky130_fd_sc_hd__decap_3
XFILLER_54_249 VSS VSS VDD VDD sky130_fd_sc_hd__decap_3
XTAP_TAPCELL_ROW_52_439 VSS VDD sky130_fd_sc_hd__tapvpwrvgnd_1
XFILLER_7_9 VSS VSS VDD VDD sky130_fd_sc_hd__decap_3
XPHY_EDGE_ROW_15_Left_73 VSS VSS VDD VDD sky130_fd_sc_hd__decap_3
XFILLER_26_21 VSS VSS VDD VDD sky130_fd_sc_hd__decap_3
XFILLER_26_32 VSS VSS VDD VDD sky130_fd_sc_hd__decap_3
XFILLER_13_113 VSS VSS VDD VDD sky130_fd_sc_hd__fill_2
XFILLER_13_135 VSS VSS VDD VDD sky130_fd_sc_hd__decap_3
XFILLER_3_36 VSS VSS VDD VDD sky130_fd_sc_hd__decap_3
XFILLER_3_69 VSS VSS VDD VDD sky130_fd_sc_hd__fill_1
XTAP_TAPCELL_ROW_8_172 VSS VDD sky130_fd_sc_hd__tapvpwrvgnd_1
XFILLER_36_227 VSS VSS VDD VDD sky130_fd_sc_hd__decap_3
XFILLER_44_282 VSS VSS VDD VDD sky130_fd_sc_hd__decap_3
XFILLER_8_150 VSS VSS VDD VDD sky130_fd_sc_hd__decap_3
X_0983_ regs\[12\]\[7\] net153 _0566_ VSS VSS VDD VDD _0119_ sky130_fd_sc_hd__mux2_1
Xfanout107 net6 VSS VSS VDD VDD net107 sky130_fd_sc_hd__clkbuf_2
Xfanout118 net120 VSS VSS VDD VDD net118 sky130_fd_sc_hd__dlymetal6s2s_1
Xfanout129 net130 VSS VSS VDD VDD net129 sky130_fd_sc_hd__clkbuf_2
XFILLER_27_249 VSS VSS VDD VDD sky130_fd_sc_hd__decap_3
X_1397_ net106 _0251_ net71 VSS VSS VDD VDD regs\[29\]\[3\] sky130_fd_sc_hd__dfrtp_1
XFILLER_50_230 VSS VSS VDD VDD sky130_fd_sc_hd__decap_3
XFILLER_12_12 VSS VSS VDD VDD sky130_fd_sc_hd__decap_3
XFILLER_12_67 VSS VSS VDD VDD sky130_fd_sc_hd__decap_3
XFILLER_50_296 VSS VSS VDD VDD sky130_fd_sc_hd__decap_3
XFILLER_5_6 VSS VSS VDD VDD sky130_fd_sc_hd__decap_3
XTAP_TAPCELL_ROW_5_153 VSS VDD sky130_fd_sc_hd__tapvpwrvgnd_1
XPHY_EDGE_ROW_0_Left_58 VSS VSS VDD VDD sky130_fd_sc_hd__decap_3
XFILLER_18_249 VSS VSS VDD VDD sky130_fd_sc_hd__decap_3
XFILLER_37_42 VSS VSS VDD VDD sky130_fd_sc_hd__decap_3
XFILLER_41_263 VSS VSS VDD VDD sky130_fd_sc_hd__decap_3
XFILLER_53_30 VSS VSS VDD VDD sky130_fd_sc_hd__decap_3
XFILLER_53_63 VSS VSS VDD VDD sky130_fd_sc_hd__decap_3
X_1320_ net94 _0174_ net59 VSS VSS VDD VDD regs\[19\]\[6\] sky130_fd_sc_hd__dfrtp_1
XTAP_TAPCELL_ROW_11_188 VSS VDD sky130_fd_sc_hd__tapvpwrvgnd_1
XFILLER_38_6 VSS VSS VDD VDD sky130_fd_sc_hd__decap_3
XFILLER_49_341 VSS VSS VDD VDD sky130_fd_sc_hd__decap_3
X_1251_ net91 _0105_ net56 VSS VSS VDD VDD regs\[11\]\[1\] sky130_fd_sc_hd__dfrtp_1
X_1182_ net96 _0036_ net61 VSS VSS VDD VDD regs\[2\]\[4\] sky130_fd_sc_hd__dfrtp_1
XFILLER_17_271 VSS VSS VDD VDD sky130_fd_sc_hd__decap_3
XFILLER_32_230 VSS VSS VDD VDD sky130_fd_sc_hd__fill_2
X_0966_ net147 _0307_ VSS VSS VDD VDD _0565_ sky130_fd_sc_hd__and2_4
X_0897_ regs\[3\]\[2\] net172 _0557_ VSS VSS VDD VDD _0042_ sky130_fd_sc_hd__mux2_1
XFILLER_55_333 VSS VSS VDD VDD sky130_fd_sc_hd__decap_3
XTAP_TAPCELL_ROW_2_134 VSS VDD sky130_fd_sc_hd__tapvpwrvgnd_1
XFILLER_23_263 VSS VSS VDD VDD sky130_fd_sc_hd__decap_3
XFILLER_23_33 VSS VSS VDD VDD sky130_fd_sc_hd__decap_3
XFILLER_23_66 VSS VSS VDD VDD sky130_fd_sc_hd__decap_3
XFILLER_2_112 VSS VSS VDD VDD sky130_fd_sc_hd__decap_3
XFILLER_2_156 VSS VSS VDD VDD sky130_fd_sc_hd__decap_3
XFILLER_3_3 VSS VSS VDD VDD sky130_fd_sc_hd__decap_3
XFILLER_0_15 VSS VSS VDD VDD sky130_fd_sc_hd__decap_3
XFILLER_48_41 VSS VSS VDD VDD sky130_fd_sc_hd__decap_3
XFILLER_48_74 VSS VSS VDD VDD sky130_fd_sc_hd__decap_3
XPHY_EDGE_ROW_45_Left_103 VSS VSS VDD VDD sky130_fd_sc_hd__decap_3
XFILLER_9_24 VSS VSS VDD VDD sky130_fd_sc_hd__decap_3
X_0820_ regs\[8\]\[6\] _0342_ _0506_ _0507_ _0508_ VSS VSS VDD VDD _0509_ sky130_fd_sc_hd__a2111o_1
X_0751_ regs\[6\]\[4\] _0297_ _0439_ _0440_ _0441_ VSS VSS VDD VDD _0442_ sky130_fd_sc_hd__a2111o_1
XPHY_EDGE_ROW_54_Left_112 VSS VSS VDD VDD sky130_fd_sc_hd__decap_3
XFILLER_9_57 VSS VSS VDD VDD sky130_fd_sc_hd__decap_3
XFILLER_36_3 VSS VSS VDD VDD sky130_fd_sc_hd__decap_3
X_1303_ net109 _0157_ net74 VSS VSS VDD VDD regs\[17\]\[5\] sky130_fd_sc_hd__dfrtp_1
X_0682_ net145 net18 _0374_ _0375_ VSS VSS VDD VDD _0009_ sky130_fd_sc_hd__a22o_1
XFILLER_37_300 VSS VSS VDD VDD sky130_fd_sc_hd__decap_3
XFILLER_49_182 VSS VSS VDD VDD sky130_fd_sc_hd__decap_3
X_1234_ net102 _0088_ net67 VSS VSS VDD VDD regs\[9\]\[0\] sky130_fd_sc_hd__dfrtp_1
X_1165_ net97 _0019_ net62 VSS VSS VDD VDD regs\[0\]\[3\] sky130_fd_sc_hd__dfrtp_1
X_1096_ regs\[25\]\[3\] net169 _0270_ VSS VSS VDD VDD _0219_ sky130_fd_sc_hd__mux2_1
XFILLER_20_277 VSS VSS VDD VDD sky130_fd_sc_hd__decap_3
X_0949_ regs\[9\]\[0\] net43 _0563_ VSS VSS VDD VDD _0088_ sky130_fd_sc_hd__mux2_1
XFILLER_18_44 VSS VSS VDD VDD sky130_fd_sc_hd__decap_3
XFILLER_28_322 VSS VSS VDD VDD sky130_fd_sc_hd__decap_3
XFILLER_47_119 VSS VSS VDD VDD sky130_fd_sc_hd__decap_3
XFILLER_18_77 VSS VSS VDD VDD sky130_fd_sc_hd__decap_3
XFILLER_34_21 VSS VSS VDD VDD sky130_fd_sc_hd__decap_3
XFILLER_34_32 VSS VSS VDD VDD sky130_fd_sc_hd__fill_1
XFILLER_43_325 VSS VSS VDD VDD sky130_fd_sc_hd__fill_2
XTAP_TAPCELL_ROW_38_350 VSS VDD sky130_fd_sc_hd__tapvpwrvgnd_1
XFILLER_11_222 VSS VSS VDD VDD sky130_fd_sc_hd__fill_2
XFILLER_11_299 VSS VSS VDD VDD sky130_fd_sc_hd__decap_3
XFILLER_50_53 VSS VSS VDD VDD sky130_fd_sc_hd__decap_3
XFILLER_7_215 VSS VSS VDD VDD sky130_fd_sc_hd__decap_3
XTAP_TAPCELL_ROW_21_250 VSS VDD sky130_fd_sc_hd__tapvpwrvgnd_1
XFILLER_22_9 VSS VSS VDD VDD sky130_fd_sc_hd__decap_3
XFILLER_34_303 VSS VSS VDD VDD sky130_fd_sc_hd__decap_3
XFILLER_46_141 VSS VSS VDD VDD sky130_fd_sc_hd__decap_3
XPHY_EDGE_ROW_3_Left_61 VSS VSS VDD VDD sky130_fd_sc_hd__decap_3
XTAP_TAPCELL_ROW_44_386 VSS VDD sky130_fd_sc_hd__tapvpwrvgnd_1
X_0803_ _0481_ _0484_ _0488_ _0492_ VSS VSS VDD VDD _0493_ sky130_fd_sc_hd__or4_1
X_0734_ net134 regs\[22\]\[3\] net32 VSS VSS VDD VDD _0426_ sky130_fd_sc_hd__and3_1
X_0665_ net133 regs\[20\]\[1\] net28 VSS VSS VDD VDD _0359_ sky130_fd_sc_hd__and3_1
X_0596_ net135 _0290_ VSS VSS VDD VDD _0291_ sky130_fd_sc_hd__and2b_2
XFILLER_52_111 VSS VSS VDD VDD sky130_fd_sc_hd__decap_3
X_1217_ net98 _0071_ net63 VSS VSS VDD VDD regs\[6\]\[7\] sky130_fd_sc_hd__dfrtp_1
X_1148_ net108 _0002_ net73 VSS VSS VDD VDD regs\[31\]\[2\] sky130_fd_sc_hd__dfrtp_1
X_1079_ regs\[23\]\[4\] net167 _0268_ VSS VSS VDD VDD _0204_ sky130_fd_sc_hd__mux2_1
XFILLER_20_12 VSS VSS VDD VDD sky130_fd_sc_hd__decap_3
XFILLER_4_229 VSS VSS VDD VDD sky130_fd_sc_hd__decap_3
XFILLER_28_141 VSS VSS VDD VDD sky130_fd_sc_hd__decap_3
XFILLER_28_163 VSS VSS VDD VDD sky130_fd_sc_hd__decap_3
XFILLER_29_21 VSS VSS VDD VDD sky130_fd_sc_hd__decap_3
XFILLER_29_87 VSS VSS VDD VDD sky130_fd_sc_hd__decap_3
XFILLER_45_42 VSS VSS VDD VDD sky130_fd_sc_hd__decap_3
XFILLER_45_86 VSS VSS VDD VDD sky130_fd_sc_hd__decap_3
XANTENNA_7 net158 VSS VSS VDD VDD sky130_fd_sc_hd__diode_2
XFILLER_6_47 VSS VSS VDD VDD sky130_fd_sc_hd__decap_3
XFILLER_6_69 VSS VSS VDD VDD sky130_fd_sc_hd__decap_3
XFILLER_20_6 VSS VSS VDD VDD sky130_fd_sc_hd__decap_3
XFILLER_3_251 VSS VSS VDD VDD sky130_fd_sc_hd__decap_3
XFILLER_19_163 VSS VSS VDD VDD sky130_fd_sc_hd__decap_3
XFILLER_19_196 VSS VSS VDD VDD sky130_fd_sc_hd__decap_3
XFILLER_22_306 VSS VSS VDD VDD sky130_fd_sc_hd__fill_2
XFILLER_34_133 VSS VSS VDD VDD sky130_fd_sc_hd__decap_3
XFILLER_34_144 VSS VSS VDD VDD sky130_fd_sc_hd__decap_3
X_1002_ net150 _0281_ VSS VSS VDD VDD _0569_ sky130_fd_sc_hd__and2_4
X_0717_ regs\[7\]\[3\] _0304_ _0307_ regs\[11\]\[3\] VSS VSS VDD VDD _0409_ sky130_fd_sc_hd__a22o_1
X_0648_ regs\[8\]\[0\] _0342_ _0341_ VSS VSS VDD VDD _0343_ sky130_fd_sc_hd__a21o_1
X_0579_ regs\[31\]\[4\] net166 _0277_ VSS VSS VDD VDD _0004_ sky130_fd_sc_hd__mux2_1
XFILLER_13_317 VSS VSS VDD VDD sky130_fd_sc_hd__decap_3
XFILLER_15_12 VSS VSS VDD VDD sky130_fd_sc_hd__decap_3
XFILLER_15_45 VSS VSS VDD VDD sky130_fd_sc_hd__decap_3
XFILLER_25_111 VSS VSS VDD VDD sky130_fd_sc_hd__fill_1
XFILLER_40_136 VSS VSS VDD VDD sky130_fd_sc_hd__decap_3
XFILLER_40_158 VSS VSS VDD VDD sky130_fd_sc_hd__decap_3
XFILLER_0_210 VSS VSS VDD VDD sky130_fd_sc_hd__decap_3
XFILLER_0_287 VSS VSS VDD VDD sky130_fd_sc_hd__decap_3
Xoutput22 net22 VSS VSS VDD VDD rdata[5] sky130_fd_sc_hd__buf_2
XFILLER_56_41 VSS VSS VDD VDD sky130_fd_sc_hd__decap_3
XFILLER_56_74 VSS VSS VDD VDD sky130_fd_sc_hd__decap_3
XFILLER_56_85 VSS VSS VDD VDD sky130_fd_sc_hd__decap_3
XFILLER_31_158 VSS VSS VDD VDD sky130_fd_sc_hd__fill_1
XFILLER_31_169 VSS VSS VDD VDD sky130_fd_sc_hd__decap_3
XFILLER_39_203 VSS VSS VDD VDD sky130_fd_sc_hd__decap_3
XFILLER_54_206 VSS VSS VDD VDD sky130_fd_sc_hd__decap_3
XFILLER_54_228 VSS VSS VDD VDD sky130_fd_sc_hd__decap_3
XFILLER_10_309 VSS VSS VDD VDD sky130_fd_sc_hd__fill_2
XFILLER_30_191 VSS VSS VDD VDD sky130_fd_sc_hd__fill_1
XFILLER_7_90 VSS VSS VDD VDD sky130_fd_sc_hd__decap_3
XFILLER_26_55 VSS VSS VDD VDD sky130_fd_sc_hd__decap_3
XFILLER_38_280 VSS VSS VDD VDD sky130_fd_sc_hd__decap_3
XFILLER_13_169 VSS VSS VDD VDD sky130_fd_sc_hd__decap_3
XFILLER_26_88 VSS VSS VDD VDD sky130_fd_sc_hd__decap_3
XFILLER_42_10 VSS VSS VDD VDD sky130_fd_sc_hd__decap_3
XFILLER_42_32 VSS VSS VDD VDD sky130_fd_sc_hd__decap_3
XFILLER_5_335 VSS VSS VDD VDD sky130_fd_sc_hd__fill_1
XFILLER_36_206 VSS VSS VDD VDD sky130_fd_sc_hd__decap_3
XFILLER_3_15 VSS VSS VDD VDD sky130_fd_sc_hd__decap_3
XFILLER_3_48 VSS VSS VDD VDD sky130_fd_sc_hd__decap_3
XTAP_TAPCELL_ROW_8_173 VSS VDD sky130_fd_sc_hd__tapvpwrvgnd_1
XPHY_EDGE_ROW_32_Left_90 VSS VSS VDD VDD sky130_fd_sc_hd__decap_3
X_0982_ regs\[12\]\[6\] net159 _0566_ VSS VSS VDD VDD _0118_ sky130_fd_sc_hd__mux2_1
Xfanout108 net116 VSS VSS VDD VDD net108 sky130_fd_sc_hd__clkbuf_2
Xfanout119 net120 VSS VSS VDD VDD net119 sky130_fd_sc_hd__clkbuf_2
XFILLER_27_228 VSS VSS VDD VDD sky130_fd_sc_hd__fill_1
X_1396_ net88 _0250_ net53 VSS VSS VDD VDD regs\[29\]\[2\] sky130_fd_sc_hd__dfrtp_1
XFILLER_50_253 VSS VSS VDD VDD sky130_fd_sc_hd__fill_2
XFILLER_50_275 VSS VSS VDD VDD sky130_fd_sc_hd__decap_3
XFILLER_12_24 VSS VSS VDD VDD sky130_fd_sc_hd__decap_3
XFILLER_12_35 VSS VSS VDD VDD sky130_fd_sc_hd__decap_3
XFILLER_2_305 VSS VSS VDD VDD sky130_fd_sc_hd__decap_3
XFILLER_2_338 VSS VSS VDD VDD sky130_fd_sc_hd__fill_2
XFILLER_18_206 VSS VSS VDD VDD sky130_fd_sc_hd__decap_3
XFILLER_37_21 VSS VSS VDD VDD sky130_fd_sc_hd__decap_3
XTAP_TAPCELL_ROW_5_154 VSS VDD sky130_fd_sc_hd__tapvpwrvgnd_1
XFILLER_37_54 VSS VSS VDD VDD sky130_fd_sc_hd__fill_2
XFILLER_53_42 VSS VSS VDD VDD sky130_fd_sc_hd__decap_3
XFILLER_41_275 VSS VSS VDD VDD sky130_fd_sc_hd__decap_3
XFILLER_41_297 VSS VSS VDD VDD sky130_fd_sc_hd__decap_3
XFILLER_53_75 VSS VSS VDD VDD sky130_fd_sc_hd__decap_3
XTAP_TAPCELL_ROW_11_189 VSS VDD sky130_fd_sc_hd__tapvpwrvgnd_1
X_1250_ net83 _0104_ net48 VSS VSS VDD VDD regs\[11\]\[0\] sky130_fd_sc_hd__dfrtp_1
X_1181_ net95 _0035_ net60 VSS VSS VDD VDD regs\[2\]\[3\] sky130_fd_sc_hd__dfrtp_1
XFILLER_17_250 VSS VSS VDD VDD sky130_fd_sc_hd__decap_3
XFILLER_32_253 VSS VSS VDD VDD sky130_fd_sc_hd__decap_3
X_0965_ regs\[10\]\[7\] net154 _0564_ VSS VSS VDD VDD _0103_ sky130_fd_sc_hd__mux2_1
X_0896_ regs\[3\]\[1\] net39 _0557_ VSS VSS VDD VDD _0041_ sky130_fd_sc_hd__mux2_1
X_1379_ net114 _0233_ net79 VSS VSS VDD VDD regs\[27\]\[1\] sky130_fd_sc_hd__dfrtp_1
XTAP_TAPCELL_ROW_2_135 VSS VDD sky130_fd_sc_hd__tapvpwrvgnd_1
XFILLER_23_12 VSS VSS VDD VDD sky130_fd_sc_hd__decap_3
XFILLER_23_253 VSS VSS VDD VDD sky130_fd_sc_hd__fill_1
XFILLER_23_275 VSS VSS VDD VDD sky130_fd_sc_hd__decap_3
XFILLER_2_168 VSS VSS VDD VDD sky130_fd_sc_hd__decap_3
XFILLER_0_27 VSS VSS VDD VDD sky130_fd_sc_hd__fill_1
XFILLER_0_38 VSS VSS VDD VDD sky130_fd_sc_hd__decap_3
XFILLER_48_53 VSS VSS VDD VDD sky130_fd_sc_hd__decap_3
XFILLER_48_97 VSS VSS VDD VDD sky130_fd_sc_hd__decap_3
XFILLER_14_220 VSS VSS VDD VDD sky130_fd_sc_hd__decap_3
XTAP_TAPCELL_ROW_24_270 VSS VDD sky130_fd_sc_hd__tapvpwrvgnd_1
XFILLER_9_36 VSS VSS VDD VDD sky130_fd_sc_hd__decap_3
XFILLER_50_6 VSS VSS VDD VDD sky130_fd_sc_hd__decap_3
Xfanout90 net6 VSS VSS VDD VDD net90 sky130_fd_sc_hd__clkbuf_2
X_0750_ net131 regs\[15\]\[4\] _0276_ VSS VSS VDD VDD _0441_ sky130_fd_sc_hd__and3b_1
X_0681_ regs\[0\]\[1\] _0327_ net145 VSS VSS VDD VDD _0375_ sky130_fd_sc_hd__o21ba_1
XFILLER_29_3 VSS VSS VDD VDD sky130_fd_sc_hd__decap_3
XFILLER_56_109 VSS VSS VDD VDD sky130_fd_sc_hd__decap_3
X_1233_ net84 _0087_ net49 VSS VSS VDD VDD regs\[8\]\[7\] sky130_fd_sc_hd__dfrtp_1
X_1302_ net89 _0156_ net54 VSS VSS VDD VDD regs\[17\]\[4\] sky130_fd_sc_hd__dfrtp_1
XFILLER_49_172 VSS VSS VDD VDD sky130_fd_sc_hd__fill_1
XFILLER_52_326 VSS VSS VDD VDD sky130_fd_sc_hd__decap_3
X_1164_ net98 _0018_ net63 VSS VSS VDD VDD regs\[0\]\[2\] sky130_fd_sc_hd__dfrtp_1
X_1095_ regs\[25\]\[2\] net174 _0270_ VSS VSS VDD VDD _0218_ sky130_fd_sc_hd__mux2_1
XFILLER_20_256 VSS VSS VDD VDD sky130_fd_sc_hd__decap_3
X_0948_ net148 _0316_ VSS VSS VDD VDD _0563_ sky130_fd_sc_hd__and2_4
X_0879_ net173 regs\[1\]\[2\] _0555_ VSS VSS VDD VDD _0026_ sky130_fd_sc_hd__mux2_1
XFILLER_18_12 VSS VSS VDD VDD sky130_fd_sc_hd__decap_3
XFILLER_18_56 VSS VSS VDD VDD sky130_fd_sc_hd__decap_3
XFILLER_28_312 VSS VSS VDD VDD sky130_fd_sc_hd__fill_1
XFILLER_34_66 VSS VSS VDD VDD sky130_fd_sc_hd__decap_3
XTAP_TAPCELL_ROW_38_351 VSS VDD sky130_fd_sc_hd__tapvpwrvgnd_1
XFILLER_11_234 VSS VSS VDD VDD sky130_fd_sc_hd__decap_3
XFILLER_11_267 VSS VSS VDD VDD sky130_fd_sc_hd__fill_2
XFILLER_50_21 VSS VSS VDD VDD sky130_fd_sc_hd__decap_3
XFILLER_50_32 VSS VSS VDD VDD sky130_fd_sc_hd__decap_3
XFILLER_50_65 VSS VSS VDD VDD sky130_fd_sc_hd__decap_3
XTAP_TAPCELL_ROW_21_251 VSS VDD sky130_fd_sc_hd__tapvpwrvgnd_1
XFILLER_38_109 VSS VSS VDD VDD sky130_fd_sc_hd__fill_2
XFILLER_15_9 VSS VSS VDD VDD sky130_fd_sc_hd__decap_3
XFILLER_19_301 VSS VSS VDD VDD sky130_fd_sc_hd__decap_3
XFILLER_46_131 VSS VSS VDD VDD sky130_fd_sc_hd__fill_2
XFILLER_46_153 VSS VSS VDD VDD sky130_fd_sc_hd__decap_3
XFILLER_46_186 VSS VSS VDD VDD sky130_fd_sc_hd__fill_2
X_0802_ regs\[4\]\[5\] _0332_ _0489_ _0490_ _0491_ VSS VSS VDD VDD _0492_ sky130_fd_sc_hd__a2111o_1
XTAP_TAPCELL_ROW_44_387 VSS VDD sky130_fd_sc_hd__tapvpwrvgnd_1
X_0733_ net133 regs\[30\]\[3\] net33 VSS VSS VDD VDD _0425_ sky130_fd_sc_hd__and3_1
X_0664_ net132 regs\[17\]\[1\] _0278_ VSS VSS VDD VDD _0358_ sky130_fd_sc_hd__and3_1
XFILLER_37_131 VSS VSS VDD VDD sky130_fd_sc_hd__decap_3
X_1216_ net111 _0070_ net76 VSS VSS VDD VDD regs\[6\]\[6\] sky130_fd_sc_hd__dfrtp_1
X_0595_ net144 net140 net142 net176 VSS VSS VDD VDD _0290_ sky130_fd_sc_hd__and4bb_2
XFILLER_1_81 VSS VSS VDD VDD sky130_fd_sc_hd__decap_3
XFILLER_25_337 VSS VSS VDD VDD sky130_fd_sc_hd__decap_3
X_1147_ net102 _0001_ net67 VSS VSS VDD VDD regs\[31\]\[1\] sky130_fd_sc_hd__dfrtp_1
X_1078_ regs\[23\]\[3\] net169 _0268_ VSS VSS VDD VDD _0203_ sky130_fd_sc_hd__mux2_1
XTAP_TAPCELL_ROW_35_332 VSS VDD sky130_fd_sc_hd__tapvpwrvgnd_1
XFILLER_20_24 VSS VSS VDD VDD sky130_fd_sc_hd__decap_3
XFILLER_29_33 VSS VSS VDD VDD sky130_fd_sc_hd__decap_3
XFILLER_28_175 VSS VSS VDD VDD sky130_fd_sc_hd__fill_1
XFILLER_29_55 VSS VSS VDD VDD sky130_fd_sc_hd__fill_1
XFILLER_45_21 VSS VSS VDD VDD sky130_fd_sc_hd__decap_3
XFILLER_45_54 VSS VSS VDD VDD sky130_fd_sc_hd__fill_2
XFILLER_43_167 VSS VSS VDD VDD sky130_fd_sc_hd__fill_1
XFILLER_45_98 VSS VSS VDD VDD sky130_fd_sc_hd__decap_3
XTAP_TAPCELL_ROW_41_368 VSS VDD sky130_fd_sc_hd__tapvpwrvgnd_1
XANTENNA_8 net164 VSS VSS VDD VDD sky130_fd_sc_hd__diode_2
XFILLER_3_241 VSS VSS VDD VDD sky130_fd_sc_hd__decap_3
XFILLER_6_15 VSS VSS VDD VDD sky130_fd_sc_hd__decap_3
XFILLER_6_59 VSS VSS VDD VDD sky130_fd_sc_hd__fill_1
XFILLER_13_6 VSS VSS VDD VDD sky130_fd_sc_hd__decap_3
XFILLER_34_112 VSS VSS VDD VDD sky130_fd_sc_hd__decap_3
XFILLER_34_156 VSS VSS VDD VDD sky130_fd_sc_hd__decap_3
X_1001_ regs\[14\]\[7\] net151 _0568_ VSS VSS VDD VDD _0135_ sky130_fd_sc_hd__mux2_1
X_0716_ regs\[13\]\[3\] _0313_ _0335_ regs\[12\]\[3\] VSS VSS VDD VDD _0408_ sky130_fd_sc_hd__a22o_1
X_0647_ net118 net25 VSS VSS VDD VDD _0342_ sky130_fd_sc_hd__and2b_4
X_0578_ regs\[31\]\[3\] net168 _0277_ VSS VSS VDD VDD _0003_ sky130_fd_sc_hd__mux2_1
XFILLER_57_215 VSS VSS VDD VDD sky130_fd_sc_hd__decap_3
XFILLER_57_237 VSS VSS VDD VDD sky130_fd_sc_hd__decap_3
XFILLER_57_259 VSS VSS VDD VDD sky130_fd_sc_hd__fill_2
XFILLER_15_24 VSS VSS VDD VDD sky130_fd_sc_hd__decap_3
XFILLER_25_167 VSS VSS VDD VDD sky130_fd_sc_hd__fill_1
XFILLER_25_178 VSS VSS VDD VDD sky130_fd_sc_hd__decap_3
XFILLER_40_115 VSS VSS VDD VDD sky130_fd_sc_hd__fill_2
XFILLER_31_12 VSS VSS VDD VDD sky130_fd_sc_hd__decap_3
Xoutput23 net23 VSS VSS VDD VDD rdata[6] sky130_fd_sc_hd__buf_2
XFILLER_0_200 VSS VSS VDD VDD sky130_fd_sc_hd__decap_3
XFILLER_0_222 VSS VSS VDD VDD sky130_fd_sc_hd__fill_2
XFILLER_0_299 VSS VSS VDD VDD sky130_fd_sc_hd__decap_3
XFILLER_48_259 VSS VSS VDD VDD sky130_fd_sc_hd__decap_3
XFILLER_16_101 VSS VSS VDD VDD sky130_fd_sc_hd__decap_3
XFILLER_56_53 VSS VSS VDD VDD sky130_fd_sc_hd__decap_3
XFILLER_56_97 VSS VSS VDD VDD sky130_fd_sc_hd__decap_3
XFILLER_11_3 VSS VSS VDD VDD sky130_fd_sc_hd__decap_3
XFILLER_39_215 VSS VSS VDD VDD sky130_fd_sc_hd__decap_3
XFILLER_39_248 VSS VSS VDD VDD sky130_fd_sc_hd__decap_3
XFILLER_22_126 VSS VSS VDD VDD sky130_fd_sc_hd__decap_3
XFILLER_26_12 VSS VSS VDD VDD sky130_fd_sc_hd__decap_3
XFILLER_26_78 VSS VSS VDD VDD sky130_fd_sc_hd__decap_3
XFILLER_38_292 VSS VSS VDD VDD sky130_fd_sc_hd__fill_1
XFILLER_53_251 VSS VSS VDD VDD sky130_fd_sc_hd__decap_3
XFILLER_42_22 VSS VSS VDD VDD sky130_fd_sc_hd__decap_3
XFILLER_42_66 VSS VSS VDD VDD sky130_fd_sc_hd__decap_3
XTAP_TAPCELL_ROW_51_430 VSS VDD sky130_fd_sc_hd__tapvpwrvgnd_1
XFILLER_3_27 VSS VSS VDD VDD sky130_fd_sc_hd__decap_3
XFILLER_29_281 VSS VSS VDD VDD sky130_fd_sc_hd__decap_3
XFILLER_36_218 VSS VSS VDD VDD sky130_fd_sc_hd__decap_3
XTAP_TAPCELL_ROW_8_174 VSS VDD sky130_fd_sc_hd__tapvpwrvgnd_1
X_0981_ regs\[12\]\[5\] net162 _0566_ VSS VSS VDD VDD _0117_ sky130_fd_sc_hd__mux2_1
XFILLER_12_170 VSS VSS VDD VDD sky130_fd_sc_hd__fill_2
XFILLER_12_192 VSS VSS VDD VDD sky130_fd_sc_hd__decap_3
XFILLER_8_141 VSS VSS VDD VDD sky130_fd_sc_hd__decap_3
X_1395_ net82 _0249_ net47 VSS VSS VDD VDD regs\[29\]\[1\] sky130_fd_sc_hd__dfrtp_1
Xfanout109 net116 VSS VSS VDD VDD net109 sky130_fd_sc_hd__clkbuf_2
XFILLER_35_262 VSS VSS VDD VDD sky130_fd_sc_hd__fill_1
XFILLER_10_118 VSS VSS VDD VDD sky130_fd_sc_hd__decap_3
XFILLER_35_284 VSS VSS VDD VDD sky130_fd_sc_hd__decap_3
XFILLER_50_221 VSS VSS VDD VDD sky130_fd_sc_hd__decap_3
XFILLER_18_218 VSS VSS VDD VDD sky130_fd_sc_hd__decap_3
XFILLER_37_33 VSS VSS VDD VDD sky130_fd_sc_hd__decap_3
XTAP_TAPCELL_ROW_5_155 VSS VDD sky130_fd_sc_hd__tapvpwrvgnd_1
XFILLER_26_251 VSS VSS VDD VDD sky130_fd_sc_hd__fill_1
XFILLER_41_221 VSS VSS VDD VDD sky130_fd_sc_hd__decap_3
XFILLER_53_21 VSS VSS VDD VDD sky130_fd_sc_hd__decap_3
XFILLER_53_54 VSS VSS VDD VDD sky130_fd_sc_hd__fill_2
XFILLER_53_87 VSS VSS VDD VDD sky130_fd_sc_hd__decap_3
XFILLER_5_122 VSS VSS VDD VDD sky130_fd_sc_hd__decap_3
XFILLER_45_9 VSS VSS VDD VDD sky130_fd_sc_hd__decap_3
XFILLER_49_321 VSS VSS VDD VDD sky130_fd_sc_hd__fill_2
XFILLER_17_262 VSS VSS VDD VDD sky130_fd_sc_hd__decap_3
X_1180_ net87 _0034_ net52 VSS VSS VDD VDD regs\[2\]\[2\] sky130_fd_sc_hd__dfrtp_1
XFILLER_17_284 VSS VSS VDD VDD sky130_fd_sc_hd__fill_2
XFILLER_17_295 VSS VSS VDD VDD sky130_fd_sc_hd__decap_3
XFILLER_32_243 VSS VSS VDD VDD sky130_fd_sc_hd__decap_3
X_0964_ regs\[10\]\[6\] net157 _0564_ VSS VSS VDD VDD _0102_ sky130_fd_sc_hd__mux2_1
X_0895_ regs\[3\]\[0\] net43 _0557_ VSS VSS VDD VDD _0040_ sky130_fd_sc_hd__mux2_1
XFILLER_55_324 VSS VSS VDD VDD sky130_fd_sc_hd__decap_3
X_1378_ net89 _0232_ net54 VSS VSS VDD VDD regs\[27\]\[0\] sky130_fd_sc_hd__dfrtp_1
XTAP_TAPCELL_ROW_2_136 VSS VDD sky130_fd_sc_hd__tapvpwrvgnd_1
XFILLER_23_24 VSS VSS VDD VDD sky130_fd_sc_hd__decap_3
XFILLER_2_103 VSS VSS VDD VDD sky130_fd_sc_hd__decap_3
XFILLER_48_21 VSS VSS VDD VDD sky130_fd_sc_hd__decap_3
XFILLER_48_32 VSS VSS VDD VDD sky130_fd_sc_hd__decap_3
XFILLER_46_302 VSS VSS VDD VDD sky130_fd_sc_hd__decap_3
XFILLER_48_65 VSS VSS VDD VDD sky130_fd_sc_hd__decap_3
XFILLER_14_232 VSS VSS VDD VDD sky130_fd_sc_hd__decap_3
Xfanout91 net99 VSS VSS VDD VDD net91 sky130_fd_sc_hd__clkbuf_2
Xfanout80 net81 VSS VSS VDD VDD net80 sky130_fd_sc_hd__buf_2
XTAP_TAPCELL_ROW_24_271 VSS VDD sky130_fd_sc_hd__tapvpwrvgnd_1
XFILLER_9_48 VSS VSS VDD VDD sky130_fd_sc_hd__decap_3
XFILLER_9_15 VSS VSS VDD VDD sky130_fd_sc_hd__decap_3
XFILLER_43_6 VSS VSS VDD VDD sky130_fd_sc_hd__decap_3
X_0680_ _0352_ _0357_ _0373_ VSS VSS VDD VDD _0374_ sky130_fd_sc_hd__or3_1
XFILLER_1_191 VSS VSS VDD VDD sky130_fd_sc_hd__fill_1
X_1232_ net83 _0086_ net48 VSS VSS VDD VDD regs\[8\]\[6\] sky130_fd_sc_hd__dfrtp_1
X_1301_ net89 _0155_ net54 VSS VSS VDD VDD regs\[17\]\[3\] sky130_fd_sc_hd__dfrtp_1
XFILLER_52_338 VSS VSS VDD VDD sky130_fd_sc_hd__decap_3
X_1163_ net93 _0017_ net58 VSS VSS VDD VDD regs\[0\]\[1\] sky130_fd_sc_hd__dfrtp_1
X_1094_ regs\[25\]\[1\] net39 _0270_ VSS VSS VDD VDD _0217_ sky130_fd_sc_hd__mux2_1
XFILLER_20_246 VSS VSS VDD VDD sky130_fd_sc_hd__decap_3
XFILLER_20_268 VSS VSS VDD VDD sky130_fd_sc_hd__decap_3
X_0947_ net151 regs\[8\]\[7\] _0562_ VSS VSS VDD VDD _0087_ sky130_fd_sc_hd__mux2_1
X_0878_ net41 regs\[1\]\[1\] _0555_ VSS VSS VDD VDD _0025_ sky130_fd_sc_hd__mux2_1
XFILLER_18_24 VSS VSS VDD VDD sky130_fd_sc_hd__decap_3
XFILLER_18_35 VSS VSS VDD VDD sky130_fd_sc_hd__decap_3
XFILLER_18_68 VSS VSS VDD VDD sky130_fd_sc_hd__decap_3
XFILLER_28_302 VSS VSS VDD VDD sky130_fd_sc_hd__decap_3
XFILLER_55_110 VSS VSS VDD VDD sky130_fd_sc_hd__fill_2
XTAP_TAPCELL_ROW_38_352 VSS VDD sky130_fd_sc_hd__tapvpwrvgnd_1
XFILLER_34_12 VSS VSS VDD VDD sky130_fd_sc_hd__decap_3
XFILLER_34_78 VSS VSS VDD VDD sky130_fd_sc_hd__decap_3
XFILLER_11_279 VSS VSS VDD VDD sky130_fd_sc_hd__fill_1
XFILLER_50_44 VSS VSS VDD VDD sky130_fd_sc_hd__decap_3
XFILLER_50_77 VSS VSS VDD VDD sky130_fd_sc_hd__decap_3
XFILLER_7_206 VSS VSS VDD VDD sky130_fd_sc_hd__decap_3
XFILLER_7_228 VSS VSS VDD VDD sky130_fd_sc_hd__decap_3
XTAP_TAPCELL_ROW_21_252 VSS VDD sky130_fd_sc_hd__tapvpwrvgnd_1
XFILLER_46_165 VSS VSS VDD VDD sky130_fd_sc_hd__fill_1
X_0801_ net128 regs\[12\]\[5\] net36 VSS VSS VDD VDD _0491_ sky130_fd_sc_hd__and3b_1
XTAP_TAPCELL_ROW_44_388 VSS VDD sky130_fd_sc_hd__tapvpwrvgnd_1
XFILLER_41_3 VSS VSS VDD VDD sky130_fd_sc_hd__decap_3
XFILLER_6_250 VSS VSS VDD VDD sky130_fd_sc_hd__fill_2
X_0732_ net133 regs\[21\]\[3\] net34 VSS VSS VDD VDD _0424_ sky130_fd_sc_hd__and3_1
X_0663_ _0353_ _0354_ _0355_ _0356_ VSS VSS VDD VDD _0357_ sky130_fd_sc_hd__or4_1
X_0594_ net131 regs\[18\]\[0\] net35 VSS VSS VDD VDD _0289_ sky130_fd_sc_hd__and3_1
XFILLER_1_60 VSS VSS VDD VDD sky130_fd_sc_hd__decap_3
XFILLER_37_165 VSS VSS VDD VDD sky130_fd_sc_hd__decap_3
X_1215_ net92 _0069_ net57 VSS VSS VDD VDD regs\[6\]\[5\] sky130_fd_sc_hd__dfrtp_1
X_1146_ net106 _0000_ net71 VSS VSS VDD VDD regs\[31\]\[0\] sky130_fd_sc_hd__dfrtp_1
XFILLER_1_93 VSS VSS VDD VDD sky130_fd_sc_hd__decap_3
XFILLER_52_135 VSS VSS VDD VDD sky130_fd_sc_hd__decap_3
X_1077_ regs\[23\]\[2\] net174 _0268_ VSS VSS VDD VDD _0202_ sky130_fd_sc_hd__mux2_1
XTAP_TAPCELL_ROW_35_333 VSS VDD sky130_fd_sc_hd__tapvpwrvgnd_1
XFILLER_29_12 VSS VSS VDD VDD sky130_fd_sc_hd__decap_3
XFILLER_29_78 VSS VSS VDD VDD sky130_fd_sc_hd__decap_3
XFILLER_16_305 VSS VSS VDD VDD sky130_fd_sc_hd__decap_3
XFILLER_28_154 VSS VSS VDD VDD sky130_fd_sc_hd__decap_3
XFILLER_31_308 VSS VSS VDD VDD sky130_fd_sc_hd__fill_2
XFILLER_45_33 VSS VSS VDD VDD sky130_fd_sc_hd__decap_3
XFILLER_45_66 VSS VSS VDD VDD sky130_fd_sc_hd__fill_2
XFILLER_45_77 VSS VSS VDD VDD sky130_fd_sc_hd__decap_3
XFILLER_31_319 VSS VSS VDD VDD sky130_fd_sc_hd__decap_3
XTAP_TAPCELL_ROW_41_369 VSS VDD sky130_fd_sc_hd__tapvpwrvgnd_1
XFILLER_6_27 VSS VSS VDD VDD sky130_fd_sc_hd__fill_1
XFILLER_6_38 VSS VSS VDD VDD sky130_fd_sc_hd__decap_3
XFILLER_19_110 VSS VSS VDD VDD sky130_fd_sc_hd__fill_2
X_1000_ regs\[14\]\[6\] net159 _0568_ VSS VSS VDD VDD _0134_ sky130_fd_sc_hd__mux2_1
XFILLER_19_187 VSS VSS VDD VDD sky130_fd_sc_hd__decap_3
XFILLER_34_124 VSS VSS VDD VDD sky130_fd_sc_hd__decap_3
XFILLER_34_168 VSS VSS VDD VDD sky130_fd_sc_hd__decap_3
XFILLER_42_190 VSS VSS VDD VDD sky130_fd_sc_hd__decap_3
XTAP_TAPCELL_ROW_32_314 VSS VDD sky130_fd_sc_hd__tapvpwrvgnd_1
XFILLER_30_341 VSS VSS VDD VDD sky130_fd_sc_hd__decap_3
X_0715_ regs\[14\]\[3\] _0294_ _0342_ regs\[8\]\[3\] VSS VSS VDD VDD _0407_ sky130_fd_sc_hd__a22o_1
X_0646_ net118 regs\[24\]\[0\] net25 VSS VSS VDD VDD _0341_ sky130_fd_sc_hd__and3_1
X_0577_ regs\[31\]\[2\] net172 _0277_ VSS VSS VDD VDD _0002_ sky130_fd_sc_hd__mux2_1
XFILLER_25_102 VSS VSS VDD VDD sky130_fd_sc_hd__decap_3
XFILLER_25_113 VSS VSS VDD VDD sky130_fd_sc_hd__fill_1
XFILLER_57_249 VSS VSS VDD VDD sky130_fd_sc_hd__decap_3
X_1129_ regs\[29\]\[0\] net43 _0274_ VSS VSS VDD VDD _0248_ sky130_fd_sc_hd__mux2_1
XFILLER_13_308 VSS VSS VDD VDD sky130_fd_sc_hd__decap_3
XFILLER_15_36 VSS VSS VDD VDD sky130_fd_sc_hd__decap_3
XFILLER_31_24 VSS VSS VDD VDD sky130_fd_sc_hd__decap_3
XFILLER_40_127 VSS VSS VDD VDD sky130_fd_sc_hd__decap_3
XFILLER_31_57 VSS VSS VDD VDD sky130_fd_sc_hd__decap_3
Xoutput24 net24 VSS VSS VDD VDD rdata[7] sky130_fd_sc_hd__buf_2
XFILLER_0_234 VSS VSS VDD VDD sky130_fd_sc_hd__decap_3
XFILLER_0_256 VSS VSS VDD VDD sky130_fd_sc_hd__decap_3
XFILLER_0_278 VSS VSS VDD VDD sky130_fd_sc_hd__fill_2
XFILLER_48_249 VSS VSS VDD VDD sky130_fd_sc_hd__decap_3
XFILLER_56_21 VSS VSS VDD VDD sky130_fd_sc_hd__decap_3
XFILLER_56_32 VSS VSS VDD VDD sky130_fd_sc_hd__decap_3
XFILLER_56_65 VSS VSS VDD VDD sky130_fd_sc_hd__decap_3
XFILLER_12_330 VSS VSS VDD VDD sky130_fd_sc_hd__decap_3
XFILLER_16_168 VSS VSS VDD VDD sky130_fd_sc_hd__decap_3
XFILLER_31_105 VSS VSS VDD VDD sky130_fd_sc_hd__decap_3
XTAP_TAPCELL_ROW_54_450 VSS VDD sky130_fd_sc_hd__tapvpwrvgnd_1
XPHY_EDGE_ROW_19_Right_19 VSS VSS VDD VDD sky130_fd_sc_hd__decap_3
XFILLER_8_323 VSS VSS VDD VDD sky130_fd_sc_hd__fill_1
XPHY_EDGE_ROW_28_Right_28 VSS VSS VDD VDD sky130_fd_sc_hd__decap_3
XPHY_EDGE_ROW_37_Right_37 VSS VSS VDD VDD sky130_fd_sc_hd__decap_3
XFILLER_7_81 VSS VSS VDD VDD sky130_fd_sc_hd__decap_3
XPHY_EDGE_ROW_46_Right_46 VSS VSS VDD VDD sky130_fd_sc_hd__decap_3
X_0629_ net129 _0283_ VSS VSS VDD VDD _0324_ sky130_fd_sc_hd__and2_4
XPHY_EDGE_ROW_55_Right_55 VSS VSS VDD VDD sky130_fd_sc_hd__decap_3
XFILLER_13_138 VSS VSS VDD VDD sky130_fd_sc_hd__decap_3
XFILLER_26_24 VSS VSS VDD VDD sky130_fd_sc_hd__decap_3
XFILLER_38_271 VSS VSS VDD VDD sky130_fd_sc_hd__decap_3
XTAP_TAPCELL_ROW_51_431 VSS VDD sky130_fd_sc_hd__tapvpwrvgnd_1
XFILLER_3_39 VSS VSS VDD VDD sky130_fd_sc_hd__decap_3
XTAP_TAPCELL_ROW_8_175 VSS VDD sky130_fd_sc_hd__tapvpwrvgnd_1
XFILLER_44_230 VSS VSS VDD VDD sky130_fd_sc_hd__decap_3
XFILLER_44_285 VSS VSS VDD VDD sky130_fd_sc_hd__decap_3
X_0980_ regs\[12\]\[4\] net166 _0566_ VSS VSS VDD VDD _0116_ sky130_fd_sc_hd__mux2_1
XFILLER_8_153 VSS VSS VDD VDD sky130_fd_sc_hd__decap_3
X_1394_ net87 _0248_ net52 VSS VSS VDD VDD regs\[29\]\[0\] sky130_fd_sc_hd__dfrtp_1
XFILLER_50_200 VSS VSS VDD VDD sky130_fd_sc_hd__decap_3
XFILLER_50_233 VSS VSS VDD VDD sky130_fd_sc_hd__decap_3
XPHY_EDGE_ROW_19_Left_77 VSS VSS VDD VDD sky130_fd_sc_hd__decap_3
XFILLER_12_15 VSS VSS VDD VDD sky130_fd_sc_hd__decap_3
XFILLER_50_299 VSS VSS VDD VDD sky130_fd_sc_hd__decap_3
XFILLER_5_9 VSS VSS VDD VDD sky130_fd_sc_hd__decap_3
XFILLER_37_12 VSS VSS VDD VDD sky130_fd_sc_hd__decap_3
XFILLER_37_45 VSS VSS VDD VDD sky130_fd_sc_hd__decap_3
XTAP_TAPCELL_ROW_5_156 VSS VDD sky130_fd_sc_hd__tapvpwrvgnd_1
XFILLER_26_241 VSS VSS VDD VDD sky130_fd_sc_hd__fill_1
XFILLER_41_266 VSS VSS VDD VDD sky130_fd_sc_hd__decap_3
XFILLER_53_33 VSS VSS VDD VDD sky130_fd_sc_hd__decap_3
XFILLER_53_66 VSS VSS VDD VDD sky130_fd_sc_hd__decap_3
XFILLER_53_99 VSS VSS VDD VDD sky130_fd_sc_hd__fill_2
XFILLER_5_189 VSS VSS VDD VDD sky130_fd_sc_hd__decap_3
XFILLER_1_340 VSS VSS VDD VDD sky130_fd_sc_hd__decap_3
XFILLER_38_9 VSS VSS VDD VDD sky130_fd_sc_hd__decap_3
XFILLER_17_241 VSS VSS VDD VDD sky130_fd_sc_hd__decap_3
XFILLER_17_274 VSS VSS VDD VDD sky130_fd_sc_hd__decap_3
XFILLER_32_200 VSS VSS VDD VDD sky130_fd_sc_hd__decap_3
XTAP_TAPCELL_ROW_19_236 VSS VDD sky130_fd_sc_hd__tapvpwrvgnd_1
X_0963_ regs\[10\]\[5\] net160 _0564_ VSS VSS VDD VDD _0101_ sky130_fd_sc_hd__mux2_1
X_0894_ net148 _0284_ VSS VSS VDD VDD _0557_ sky130_fd_sc_hd__and2_4
XFILLER_4_82 VSS VSS VDD VDD sky130_fd_sc_hd__fill_2
X_1377_ net88 _0231_ net53 VSS VSS VDD VDD regs\[26\]\[7\] sky130_fd_sc_hd__dfrtp_1
XTAP_TAPCELL_ROW_2_137 VSS VDD sky130_fd_sc_hd__tapvpwrvgnd_1
XFILLER_2_115 VSS VSS VDD VDD sky130_fd_sc_hd__decap_3
XFILLER_3_6 VSS VSS VDD VDD sky130_fd_sc_hd__decap_3
XFILLER_48_44 VSS VSS VDD VDD sky130_fd_sc_hd__decap_3
XFILLER_0_18 VSS VSS VDD VDD sky130_fd_sc_hd__decap_3
XFILLER_0_29 VSS VSS VDD VDD sky130_fd_sc_hd__decap_3
XFILLER_14_200 VSS VSS VDD VDD sky130_fd_sc_hd__fill_2
XFILLER_14_211 VSS VSS VDD VDD sky130_fd_sc_hd__decap_3
XFILLER_48_77 VSS VSS VDD VDD sky130_fd_sc_hd__decap_3
Xfanout92 net99 VSS VSS VDD VDD net92 sky130_fd_sc_hd__dlymetal6s2s_1
Xfanout81 net7 VSS VSS VDD VDD net81 sky130_fd_sc_hd__buf_2
Xfanout70 net71 VSS VSS VDD VDD net70 sky130_fd_sc_hd__buf_2
XFILLER_9_27 VSS VSS VDD VDD sky130_fd_sc_hd__decap_3
XFILLER_13_91 VSS VSS VDD VDD sky130_fd_sc_hd__decap_3
XFILLER_36_6 VSS VSS VDD VDD sky130_fd_sc_hd__decap_3
XFILLER_37_303 VSS VSS VDD VDD sky130_fd_sc_hd__decap_3
XFILLER_49_152 VSS VSS VDD VDD sky130_fd_sc_hd__decap_3
X_1231_ net82 _0085_ net47 VSS VSS VDD VDD regs\[8\]\[5\] sky130_fd_sc_hd__dfrtp_1
X_1300_ net109 _0154_ net74 VSS VSS VDD VDD regs\[17\]\[2\] sky130_fd_sc_hd__dfrtp_1
X_1162_ net94 _0016_ net59 VSS VSS VDD VDD regs\[0\]\[0\] sky130_fd_sc_hd__dfrtp_1
X_1093_ regs\[25\]\[0\] net43 _0270_ VSS VSS VDD VDD _0216_ sky130_fd_sc_hd__mux2_1
X_0946_ net156 regs\[8\]\[6\] _0562_ VSS VSS VDD VDD _0086_ sky130_fd_sc_hd__mux2_1
X_0877_ net46 regs\[1\]\[0\] _0555_ VSS VSS VDD VDD _0024_ sky130_fd_sc_hd__mux2_1
XFILLER_9_281 VSS VSS VDD VDD sky130_fd_sc_hd__fill_1
XFILLER_18_47 VSS VSS VDD VDD sky130_fd_sc_hd__decap_3
XFILLER_28_325 VSS VSS VDD VDD sky130_fd_sc_hd__decap_3
XTAP_TAPCELL_ROW_38_353 VSS VDD sky130_fd_sc_hd__tapvpwrvgnd_1
XFILLER_11_225 VSS VSS VDD VDD sky130_fd_sc_hd__decap_3
XFILLER_34_24 VSS VSS VDD VDD sky130_fd_sc_hd__decap_3
XFILLER_50_12 VSS VSS VDD VDD sky130_fd_sc_hd__decap_3
XFILLER_7_218 VSS VSS VDD VDD sky130_fd_sc_hd__decap_3
XTAP_TAPCELL_ROW_21_253 VSS VDD sky130_fd_sc_hd__tapvpwrvgnd_1
XFILLER_1_3 VSS VSS VDD VDD sky130_fd_sc_hd__decap_3
XFILLER_50_56 VSS VSS VDD VDD sky130_fd_sc_hd__decap_3
XFILLER_34_306 VSS VSS VDD VDD sky130_fd_sc_hd__fill_2
XFILLER_46_144 VSS VSS VDD VDD sky130_fd_sc_hd__decap_3
XTAP_TAPCELL_ROW_44_389 VSS VDD sky130_fd_sc_hd__tapvpwrvgnd_1
X_0800_ net128 regs\[31\]\[5\] net38 VSS VSS VDD VDD _0490_ sky130_fd_sc_hd__and3_1
X_0731_ regs\[5\]\[3\] _0291_ _0326_ _0421_ _0422_ VSS VSS VDD VDD _0423_ sky130_fd_sc_hd__a2111o_1
XFILLER_34_3 VSS VSS VDD VDD sky130_fd_sc_hd__decap_3
X_0662_ regs\[13\]\[1\] _0313_ _0316_ regs\[9\]\[1\] VSS VSS VDD VDD _0356_ sky130_fd_sc_hd__a22o_1
X_0593_ net176 net142 net140 net144 VSS VSS VDD VDD _0288_ sky130_fd_sc_hd__nor4b_2
XFILLER_1_72 VSS VSS VDD VDD sky130_fd_sc_hd__decap_3
XFILLER_37_155 VSS VSS VDD VDD sky130_fd_sc_hd__fill_1
XFILLER_52_114 VSS VSS VDD VDD sky130_fd_sc_hd__fill_1
X_1214_ net110 _0068_ net75 VSS VSS VDD VDD regs\[6\]\[4\] sky130_fd_sc_hd__dfrtp_1
X_1145_ regs\[30\]\[7\] net155 _0275_ VSS VSS VDD VDD _0263_ sky130_fd_sc_hd__mux2_1
X_1076_ regs\[23\]\[1\] net39 _0268_ VSS VSS VDD VDD _0201_ sky130_fd_sc_hd__mux2_1
XTAP_TAPCELL_ROW_35_334 VSS VDD sky130_fd_sc_hd__tapvpwrvgnd_1
XFILLER_20_15 VSS VSS VDD VDD sky130_fd_sc_hd__decap_3
X_0929_ regs\[6\]\[7\] net154 _0560_ VSS VSS VDD VDD _0071_ sky130_fd_sc_hd__mux2_1
XFILLER_28_100 VSS VSS VDD VDD sky130_fd_sc_hd__decap_3
XFILLER_29_24 VSS VSS VDD VDD sky130_fd_sc_hd__decap_3
XFILLER_29_57 VSS VSS VDD VDD sky130_fd_sc_hd__decap_3
XFILLER_28_144 VSS VSS VDD VDD sky130_fd_sc_hd__fill_1
XFILLER_43_169 VSS VSS VDD VDD sky130_fd_sc_hd__fill_1
XFILLER_45_12 VSS VSS VDD VDD sky130_fd_sc_hd__decap_3
XFILLER_45_45 VSS VSS VDD VDD sky130_fd_sc_hd__decap_3
XFILLER_45_89 VSS VSS VDD VDD sky130_fd_sc_hd__decap_3
XPHY_EDGE_ROW_7_Left_65 VSS VSS VDD VDD sky130_fd_sc_hd__decap_3
XFILLER_3_221 VSS VSS VDD VDD sky130_fd_sc_hd__decap_3
XFILLER_3_254 VSS VSS VDD VDD sky130_fd_sc_hd__decap_3
XFILLER_19_166 VSS VSS VDD VDD sky130_fd_sc_hd__fill_2
XFILLER_19_199 VSS VSS VDD VDD sky130_fd_sc_hd__decap_3
XFILLER_20_9 VSS VSS VDD VDD sky130_fd_sc_hd__decap_3
XTAP_TAPCELL_ROW_57_470 VSS VDD sky130_fd_sc_hd__tapvpwrvgnd_1
XFILLER_34_136 VSS VSS VDD VDD sky130_fd_sc_hd__decap_3
XFILLER_34_147 VSS VSS VDD VDD sky130_fd_sc_hd__decap_3
XTAP_TAPCELL_ROW_32_315 VSS VDD sky130_fd_sc_hd__tapvpwrvgnd_1
X_0714_ net147 net19 _0405_ _0406_ VSS VSS VDD VDD _0010_ sky130_fd_sc_hd__a22o_1
X_0645_ net143 net175 net141 net139 VSS VSS VDD VDD _0340_ sky130_fd_sc_hd__nor4b_2
XFILLER_57_206 VSS VSS VDD VDD sky130_fd_sc_hd__decap_3
X_0576_ regs\[31\]\[1\] net39 _0277_ VSS VSS VDD VDD _0001_ sky130_fd_sc_hd__mux2_1
XFILLER_15_15 VSS VSS VDD VDD sky130_fd_sc_hd__decap_3
XFILLER_15_48 VSS VSS VDD VDD sky130_fd_sc_hd__decap_3
X_1128_ net117 net148 net30 VSS VSS VDD VDD _0274_ sky130_fd_sc_hd__and3_4
X_1059_ regs\[21\]\[2\] net174 _0266_ VSS VSS VDD VDD _0186_ sky130_fd_sc_hd__mux2_1
XFILLER_40_139 VSS VSS VDD VDD sky130_fd_sc_hd__fill_1
XFILLER_0_213 VSS VSS VDD VDD sky130_fd_sc_hd__decap_3
XFILLER_56_44 VSS VSS VDD VDD sky130_fd_sc_hd__decap_3
XFILLER_56_77 VSS VSS VDD VDD sky130_fd_sc_hd__decap_3
XFILLER_56_88 VSS VSS VDD VDD sky130_fd_sc_hd__decap_3
XFILLER_8_302 VSS VSS VDD VDD sky130_fd_sc_hd__decap_3
XTAP_TAPCELL_ROW_54_451 VSS VDD sky130_fd_sc_hd__tapvpwrvgnd_1
XFILLER_21_91 VSS VSS VDD VDD sky130_fd_sc_hd__decap_3
XFILLER_39_206 VSS VSS VDD VDD sky130_fd_sc_hd__decap_3
XFILLER_54_209 VSS VSS VDD VDD sky130_fd_sc_hd__decap_3
XFILLER_30_150 VSS VSS VDD VDD sky130_fd_sc_hd__decap_3
XFILLER_7_93 VSS VSS VDD VDD sky130_fd_sc_hd__decap_3
X_0628_ net128 regs\[31\]\[0\] net38 _0322_ VSS VSS VDD VDD _0323_ sky130_fd_sc_hd__a31o_1
XFILLER_38_283 VSS VSS VDD VDD sky130_fd_sc_hd__decap_3
XFILLER_42_13 VSS VSS VDD VDD sky130_fd_sc_hd__decap_3
XFILLER_42_35 VSS VSS VDD VDD sky130_fd_sc_hd__decap_3
XTAP_TAPCELL_ROW_51_432 VSS VDD sky130_fd_sc_hd__tapvpwrvgnd_1
XFILLER_21_150 VSS VSS VDD VDD sky130_fd_sc_hd__decap_3
XFILLER_21_172 VSS VSS VDD VDD sky130_fd_sc_hd__decap_3
XFILLER_21_194 VSS VSS VDD VDD sky130_fd_sc_hd__fill_2
XFILLER_42_79 VSS VSS VDD VDD sky130_fd_sc_hd__decap_3
XFILLER_3_18 VSS VSS VDD VDD sky130_fd_sc_hd__decap_3
XFILLER_36_209 VSS VSS VDD VDD sky130_fd_sc_hd__decap_3
XFILLER_44_242 VSS VSS VDD VDD sky130_fd_sc_hd__decap_3
XFILLER_8_110 VSS VSS VDD VDD sky130_fd_sc_hd__decap_3
XFILLER_8_121 VSS VSS VDD VDD sky130_fd_sc_hd__decap_3
X_1393_ net88 _0247_ net53 VSS VSS VDD VDD regs\[28\]\[7\] sky130_fd_sc_hd__dfrtp_1
XFILLER_50_212 VSS VSS VDD VDD sky130_fd_sc_hd__decap_3
XFILLER_12_27 VSS VSS VDD VDD sky130_fd_sc_hd__fill_1
XFILLER_12_38 VSS VSS VDD VDD sky130_fd_sc_hd__fill_2
XFILLER_50_278 VSS VSS VDD VDD sky130_fd_sc_hd__fill_2
XFILLER_18_209 VSS VSS VDD VDD sky130_fd_sc_hd__decap_3
XFILLER_26_253 VSS VSS VDD VDD sky130_fd_sc_hd__decap_3
XFILLER_37_24 VSS VSS VDD VDD sky130_fd_sc_hd__decap_3
XFILLER_37_57 VSS VSS VDD VDD sky130_fd_sc_hd__decap_3
XTAP_TAPCELL_ROW_5_157 VSS VDD sky130_fd_sc_hd__tapvpwrvgnd_1
XFILLER_41_278 VSS VSS VDD VDD sky130_fd_sc_hd__fill_2
XFILLER_53_12 VSS VSS VDD VDD sky130_fd_sc_hd__decap_3
XFILLER_53_45 VSS VSS VDD VDD sky130_fd_sc_hd__decap_3
XFILLER_53_78 VSS VSS VDD VDD sky130_fd_sc_hd__decap_3
XFILLER_5_146 VSS VSS VDD VDD sky130_fd_sc_hd__fill_2
XPHY_EDGE_ROW_36_Left_94 VSS VSS VDD VDD sky130_fd_sc_hd__decap_3
XFILLER_17_253 VSS VSS VDD VDD sky130_fd_sc_hd__decap_3
XFILLER_32_256 VSS VSS VDD VDD sky130_fd_sc_hd__decap_3
XTAP_TAPCELL_ROW_19_237 VSS VDD sky130_fd_sc_hd__tapvpwrvgnd_1
XPHY_EDGE_ROW_20_Left_78 VSS VSS VDD VDD sky130_fd_sc_hd__decap_3
X_0962_ regs\[10\]\[4\] net165 _0564_ VSS VSS VDD VDD _0100_ sky130_fd_sc_hd__mux2_1
X_0893_ net151 regs\[2\]\[7\] _0556_ VSS VSS VDD VDD _0039_ sky130_fd_sc_hd__mux2_1
XFILLER_4_50 VSS VSS VDD VDD sky130_fd_sc_hd__decap_3
XFILLER_4_94 VSS VSS VDD VDD sky130_fd_sc_hd__decap_3
XFILLER_55_337 VSS VSS VDD VDD sky130_fd_sc_hd__decap_3
X_1376_ net84 _0230_ net49 VSS VSS VDD VDD regs\[26\]\[6\] sky130_fd_sc_hd__dfrtp_1
XTAP_TAPCELL_ROW_2_138 VSS VDD sky130_fd_sc_hd__tapvpwrvgnd_1
XFILLER_23_15 VSS VSS VDD VDD sky130_fd_sc_hd__decap_3
XFILLER_23_278 VSS VSS VDD VDD sky130_fd_sc_hd__fill_2
XFILLER_48_12 VSS VSS VDD VDD sky130_fd_sc_hd__decap_3
XFILLER_48_56 VSS VSS VDD VDD sky130_fd_sc_hd__decap_3
XFILLER_14_223 VSS VSS VDD VDD sky130_fd_sc_hd__decap_3
XFILLER_14_245 VSS VSS VDD VDD sky130_fd_sc_hd__decap_3
XTAP_TAPCELL_ROW_16_218 VSS VDD sky130_fd_sc_hd__tapvpwrvgnd_1
Xfanout93 net94 VSS VSS VDD VDD net93 sky130_fd_sc_hd__clkbuf_2
Xfanout82 net85 VSS VSS VDD VDD net82 sky130_fd_sc_hd__clkbuf_2
Xfanout71 net72 VSS VSS VDD VDD net71 sky130_fd_sc_hd__clkbuf_4
Xfanout60 net64 VSS VSS VDD VDD net60 sky130_fd_sc_hd__clkbuf_4
XFILLER_9_39 VSS VSS VDD VDD sky130_fd_sc_hd__decap_3
XFILLER_50_9 VSS VSS VDD VDD sky130_fd_sc_hd__decap_3
XFILLER_29_6 VSS VSS VDD VDD sky130_fd_sc_hd__decap_3
XFILLER_37_326 VSS VSS VDD VDD sky130_fd_sc_hd__fill_1
XFILLER_49_131 VSS VSS VDD VDD sky130_fd_sc_hd__fill_1
XFILLER_52_307 VSS VSS VDD VDD sky130_fd_sc_hd__fill_1
X_1230_ net92 _0084_ net57 VSS VSS VDD VDD regs\[8\]\[4\] sky130_fd_sc_hd__dfrtp_1
X_1161_ net97 _0015_ net62 VSS VSS VDD VDD net24 sky130_fd_sc_hd__dfrtp_1
X_1092_ net117 net148 net29 VSS VSS VDD VDD _0270_ sky130_fd_sc_hd__and3_4
XFILLER_52_329 VSS VSS VDD VDD sky130_fd_sc_hd__decap_3
XFILLER_20_259 VSS VSS VDD VDD sky130_fd_sc_hd__decap_3
X_0945_ net161 regs\[8\]\[5\] _0562_ VSS VSS VDD VDD _0085_ sky130_fd_sc_hd__mux2_1
X_0876_ net145 _0299_ VSS VSS VDD VDD _0555_ sky130_fd_sc_hd__nand2_4
XFILLER_9_260 VSS VSS VDD VDD sky130_fd_sc_hd__fill_2
XFILLER_18_15 VSS VSS VDD VDD sky130_fd_sc_hd__decap_3
XFILLER_18_59 VSS VSS VDD VDD sky130_fd_sc_hd__decap_3
XFILLER_55_101 VSS VSS VDD VDD sky130_fd_sc_hd__decap_3
X_1359_ net101 _0213_ net66 VSS VSS VDD VDD regs\[24\]\[5\] sky130_fd_sc_hd__dfrtp_1
XTAP_TAPCELL_ROW_38_354 VSS VDD sky130_fd_sc_hd__tapvpwrvgnd_1
XFILLER_11_237 VSS VSS VDD VDD sky130_fd_sc_hd__decap_3
XFILLER_34_69 VSS VSS VDD VDD sky130_fd_sc_hd__decap_3
XFILLER_50_24 VSS VSS VDD VDD sky130_fd_sc_hd__decap_3
XFILLER_50_35 VSS VSS VDD VDD sky130_fd_sc_hd__decap_3
XFILLER_50_68 VSS VSS VDD VDD sky130_fd_sc_hd__decap_3
XFILLER_19_304 VSS VSS VDD VDD sky130_fd_sc_hd__decap_3
XFILLER_19_337 VSS VSS VDD VDD sky130_fd_sc_hd__decap_3
XFILLER_10_281 VSS VSS VDD VDD sky130_fd_sc_hd__decap_3
XFILLER_24_80 VSS VSS VDD VDD sky130_fd_sc_hd__decap_3
XFILLER_24_91 VSS VSS VDD VDD sky130_fd_sc_hd__decap_3
XFILLER_6_241 VSS VSS VDD VDD sky130_fd_sc_hd__decap_3
XFILLER_6_285 VSS VSS VDD VDD sky130_fd_sc_hd__decap_3
X_0730_ net129 regs\[20\]\[3\] _0319_ VSS VSS VDD VDD _0422_ sky130_fd_sc_hd__and3_1
X_0661_ regs\[6\]\[1\] _0297_ _0342_ regs\[8\]\[1\] VSS VSS VDD VDD _0355_ sky130_fd_sc_hd__a22o_1
XFILLER_27_3 VSS VSS VDD VDD sky130_fd_sc_hd__decap_3
X_1213_ net98 _0067_ net63 VSS VSS VDD VDD regs\[6\]\[3\] sky130_fd_sc_hd__dfrtp_1
X_0592_ regs\[3\]\[0\] _0284_ _0286_ _0280_ _0282_ VSS VSS VDD VDD _0287_ sky130_fd_sc_hd__a2111o_1
XFILLER_1_51 VSS VSS VDD VDD sky130_fd_sc_hd__decap_3
XFILLER_1_84 VSS VSS VDD VDD sky130_fd_sc_hd__decap_3
XFILLER_25_318 VSS VSS VDD VDD sky130_fd_sc_hd__decap_3
XFILLER_37_134 VSS VSS VDD VDD sky130_fd_sc_hd__decap_3
X_1144_ regs\[30\]\[6\] net157 _0275_ VSS VSS VDD VDD _0262_ sky130_fd_sc_hd__mux2_1
X_1075_ regs\[23\]\[0\] net44 _0268_ VSS VSS VDD VDD _0200_ sky130_fd_sc_hd__mux2_1
XTAP_TAPCELL_ROW_35_335 VSS VDD sky130_fd_sc_hd__tapvpwrvgnd_1
XPHY_EDGE_ROW_23_Left_81 VSS VSS VDD VDD sky130_fd_sc_hd__decap_3
XFILLER_20_27 VSS VSS VDD VDD sky130_fd_sc_hd__fill_1
X_0928_ regs\[6\]\[6\] net158 _0560_ VSS VSS VDD VDD _0070_ sky130_fd_sc_hd__mux2_1
X_0859_ net122 regs\[25\]\[7\] net29 VSS VSS VDD VDD _0547_ sky130_fd_sc_hd__and3_1
XFILLER_29_36 VSS VSS VDD VDD sky130_fd_sc_hd__decap_3
XFILLER_45_24 VSS VSS VDD VDD sky130_fd_sc_hd__decap_3
XFILLER_45_57 VSS VSS VDD VDD sky130_fd_sc_hd__decap_3
XPHY_EDGE_ROW_51_Left_109 VSS VSS VDD VDD sky130_fd_sc_hd__decap_3
XFILLER_6_18 VSS VSS VDD VDD sky130_fd_sc_hd__decap_3
XFILLER_6_29 VSS VSS VDD VDD sky130_fd_sc_hd__decap_3
XFILLER_10_71 VSS VSS VDD VDD sky130_fd_sc_hd__fill_2
XFILLER_10_82 VSS VSS VDD VDD sky130_fd_sc_hd__fill_2
XFILLER_3_277 VSS VSS VDD VDD sky130_fd_sc_hd__decap_3
XFILLER_3_299 VSS VSS VDD VDD sky130_fd_sc_hd__decap_3
XFILLER_13_9 VSS VSS VDD VDD sky130_fd_sc_hd__decap_3
XFILLER_19_101 VSS VSS VDD VDD sky130_fd_sc_hd__decap_3
XFILLER_19_178 VSS VSS VDD VDD sky130_fd_sc_hd__decap_3
XFILLER_34_115 VSS VSS VDD VDD sky130_fd_sc_hd__decap_3
XTAP_TAPCELL_ROW_57_471 VSS VDD sky130_fd_sc_hd__tapvpwrvgnd_1
XTAP_TAPCELL_ROW_49_416 VSS VDD sky130_fd_sc_hd__tapvpwrvgnd_1
XFILLER_30_332 VSS VSS VDD VDD sky130_fd_sc_hd__decap_3
XFILLER_34_159 VSS VSS VDD VDD sky130_fd_sc_hd__decap_3
XFILLER_42_170 VSS VSS VDD VDD sky130_fd_sc_hd__decap_3
XTAP_TAPCELL_ROW_32_316 VSS VDD sky130_fd_sc_hd__tapvpwrvgnd_1
X_0713_ regs\[0\]\[2\] _0327_ net147 VSS VSS VDD VDD _0406_ sky130_fd_sc_hd__o21ba_1
X_0644_ net124 regs\[16\]\[0\] net26 _0338_ regs\[10\]\[0\] VSS VSS VDD VDD _0339_
+ sky130_fd_sc_hd__a32o_1
XFILLER_57_218 VSS VSS VDD VDD sky130_fd_sc_hd__decap_3
X_0575_ regs\[31\]\[0\] net44 _0277_ VSS VSS VDD VDD _0000_ sky130_fd_sc_hd__mux2_1
XFILLER_15_27 VSS VSS VDD VDD sky130_fd_sc_hd__decap_3
XFILLER_25_137 VSS VSS VDD VDD sky130_fd_sc_hd__decap_3
XFILLER_33_181 VSS VSS VDD VDD sky130_fd_sc_hd__fill_1
X_1127_ regs\[28\]\[7\] net151 _0273_ VSS VSS VDD VDD _0247_ sky130_fd_sc_hd__mux2_1
X_1058_ regs\[21\]\[1\] net40 _0266_ VSS VSS VDD VDD _0185_ sky130_fd_sc_hd__mux2_1
XFILLER_31_15 VSS VSS VDD VDD sky130_fd_sc_hd__decap_3
XFILLER_0_203 VSS VSS VDD VDD sky130_fd_sc_hd__fill_1
XFILLER_0_225 VSS VSS VDD VDD sky130_fd_sc_hd__decap_3
XPHY_EDGE_ROW_1_Right_1 VSS VSS VDD VDD sky130_fd_sc_hd__decap_3
XFILLER_16_104 VSS VSS VDD VDD sky130_fd_sc_hd__fill_2
XFILLER_56_12 VSS VSS VDD VDD sky130_fd_sc_hd__decap_3
XFILLER_56_56 VSS VSS VDD VDD sky130_fd_sc_hd__decap_3
XFILLER_11_6 VSS VSS VDD VDD sky130_fd_sc_hd__decap_3
XFILLER_39_218 VSS VSS VDD VDD sky130_fd_sc_hd__decap_3
XFILLER_22_129 VSS VSS VDD VDD sky130_fd_sc_hd__fill_2
XFILLER_15_192 VSS VSS VDD VDD sky130_fd_sc_hd__fill_2
XFILLER_30_162 VSS VSS VDD VDD sky130_fd_sc_hd__decap_3
XFILLER_7_72 VSS VSS VDD VDD sky130_fd_sc_hd__decap_3
X_0627_ net128 regs\[21\]\[0\] net34 VSS VSS VDD VDD _0322_ sky130_fd_sc_hd__and3_1
XFILLER_26_15 VSS VSS VDD VDD sky130_fd_sc_hd__decap_3
XFILLER_38_240 VSS VSS VDD VDD sky130_fd_sc_hd__decap_3
XFILLER_38_262 VSS VSS VDD VDD sky130_fd_sc_hd__decap_3
XFILLER_53_221 VSS VSS VDD VDD sky130_fd_sc_hd__decap_3
XFILLER_13_107 VSS VSS VDD VDD sky130_fd_sc_hd__decap_3
XFILLER_42_25 VSS VSS VDD VDD sky130_fd_sc_hd__decap_3
XFILLER_42_69 VSS VSS VDD VDD sky130_fd_sc_hd__decap_3
XFILLER_53_254 VSS VSS VDD VDD sky130_fd_sc_hd__fill_2
XTAP_TAPCELL_ROW_51_433 VSS VDD sky130_fd_sc_hd__tapvpwrvgnd_1
XFILLER_16_70 VSS VSS VDD VDD sky130_fd_sc_hd__decap_3
XFILLER_29_240 VSS VSS VDD VDD sky130_fd_sc_hd__decap_3
XFILLER_29_284 VSS VSS VDD VDD sky130_fd_sc_hd__decap_3
XFILLER_12_195 VSS VSS VDD VDD sky130_fd_sc_hd__fill_1
XFILLER_16_92 VSS VSS VDD VDD sky130_fd_sc_hd__decap_3
XFILLER_8_144 VSS VSS VDD VDD sky130_fd_sc_hd__decap_3
X_1392_ net100 _0246_ net65 VSS VSS VDD VDD regs\[28\]\[6\] sky130_fd_sc_hd__dfrtp_1
XFILLER_35_287 VSS VSS VDD VDD sky130_fd_sc_hd__fill_2
XFILLER_50_224 VSS VSS VDD VDD sky130_fd_sc_hd__decap_3
XFILLER_26_265 VSS VSS VDD VDD sky130_fd_sc_hd__decap_3
XFILLER_37_36 VSS VSS VDD VDD sky130_fd_sc_hd__decap_3
XFILLER_53_24 VSS VSS VDD VDD sky130_fd_sc_hd__decap_3
XFILLER_53_57 VSS VSS VDD VDD sky130_fd_sc_hd__decap_3
XFILLER_5_125 VSS VSS VDD VDD sky130_fd_sc_hd__fill_1
XFILLER_5_169 VSS VSS VDD VDD sky130_fd_sc_hd__decap_3
XTAP_TAPCELL_ROW_19_238 VSS VDD sky130_fd_sc_hd__tapvpwrvgnd_1
XFILLER_17_265 VSS VSS VDD VDD sky130_fd_sc_hd__decap_3
XFILLER_17_298 VSS VSS VDD VDD sky130_fd_sc_hd__decap_3
XFILLER_32_246 VSS VSS VDD VDD sky130_fd_sc_hd__decap_3
XFILLER_32_279 VSS VSS VDD VDD sky130_fd_sc_hd__decap_3
X_0961_ regs\[10\]\[3\] net170 _0564_ VSS VSS VDD VDD _0099_ sky130_fd_sc_hd__mux2_1
XFILLER_57_3 VSS VSS VDD VDD sky130_fd_sc_hd__decap_3
X_0892_ net156 regs\[2\]\[6\] _0556_ VSS VSS VDD VDD _0038_ sky130_fd_sc_hd__mux2_1
XTAP_TAPCELL_ROW_10_182 VSS VDD sky130_fd_sc_hd__tapvpwrvgnd_1
XFILLER_4_191 VSS VSS VDD VDD sky130_fd_sc_hd__decap_3
X_1375_ net91 _0229_ net56 VSS VSS VDD VDD regs\[26\]\[5\] sky130_fd_sc_hd__dfrtp_1
XFILLER_23_202 VSS VSS VDD VDD sky130_fd_sc_hd__fill_2
XFILLER_55_327 VSS VSS VDD VDD sky130_fd_sc_hd__decap_3
XTAP_TAPCELL_ROW_2_139 VSS VDD sky130_fd_sc_hd__tapvpwrvgnd_1
XFILLER_23_27 VSS VSS VDD VDD sky130_fd_sc_hd__decap_3
XFILLER_2_106 VSS VSS VDD VDD sky130_fd_sc_hd__decap_3
XFILLER_46_305 VSS VSS VDD VDD sky130_fd_sc_hd__decap_3
XFILLER_48_24 VSS VSS VDD VDD sky130_fd_sc_hd__decap_3
XFILLER_48_35 VSS VSS VDD VDD sky130_fd_sc_hd__decap_3
XFILLER_48_68 VSS VSS VDD VDD sky130_fd_sc_hd__decap_3
XFILLER_14_235 VSS VSS VDD VDD sky130_fd_sc_hd__fill_1
XTAP_TAPCELL_ROW_16_219 VSS VDD sky130_fd_sc_hd__tapvpwrvgnd_1
XFILLER_9_18 VSS VSS VDD VDD sky130_fd_sc_hd__decap_3
XFILLER_13_60 VSS VSS VDD VDD sky130_fd_sc_hd__decap_3
Xfanout94 net99 VSS VSS VDD VDD net94 sky130_fd_sc_hd__clkbuf_2
Xfanout83 net85 VSS VSS VDD VDD net83 sky130_fd_sc_hd__clkbuf_2
Xfanout72 net7 VSS VSS VDD VDD net72 sky130_fd_sc_hd__clkbuf_2
Xfanout61 net64 VSS VSS VDD VDD net61 sky130_fd_sc_hd__buf_2
Xfanout50 net55 VSS VSS VDD VDD net50 sky130_fd_sc_hd__clkbuf_2
XFILLER_43_9 VSS VSS VDD VDD sky130_fd_sc_hd__decap_3
X_1160_ net94 _0014_ net59 VSS VSS VDD VDD net23 sky130_fd_sc_hd__dfrtp_1
X_1091_ regs\[24\]\[7\] net151 _0269_ VSS VSS VDD VDD _0215_ sky130_fd_sc_hd__mux2_1
XFILLER_20_249 VSS VSS VDD VDD sky130_fd_sc_hd__decap_3
X_0944_ net164 regs\[8\]\[4\] _0562_ VSS VSS VDD VDD _0084_ sky130_fd_sc_hd__mux2_1
X_0875_ net154 regs\[0\]\[7\] _0554_ VSS VSS VDD VDD _0023_ sky130_fd_sc_hd__mux2_1
XFILLER_18_27 VSS VSS VDD VDD sky130_fd_sc_hd__fill_1
XFILLER_18_38 VSS VSS VDD VDD sky130_fd_sc_hd__decap_3
XFILLER_28_305 VSS VSS VDD VDD sky130_fd_sc_hd__decap_3
XFILLER_55_113 VSS VSS VDD VDD sky130_fd_sc_hd__decap_3
X_1358_ net101 _0212_ net66 VSS VSS VDD VDD regs\[24\]\[4\] sky130_fd_sc_hd__dfrtp_1
XFILLER_34_15 VSS VSS VDD VDD sky130_fd_sc_hd__decap_3
XFILLER_51_341 VSS VSS VDD VDD sky130_fd_sc_hd__decap_3
X_1289_ net108 _0143_ net73 VSS VSS VDD VDD regs\[15\]\[7\] sky130_fd_sc_hd__dfrtp_1
XTAP_TAPCELL_ROW_38_355 VSS VDD sky130_fd_sc_hd__tapvpwrvgnd_1
XFILLER_50_47 VSS VSS VDD VDD sky130_fd_sc_hd__decap_3
XFILLER_7_209 VSS VSS VDD VDD sky130_fd_sc_hd__decap_3
XTAP_TAPCELL_ROW_29_300 VSS VDD sky130_fd_sc_hd__tapvpwrvgnd_1
XFILLER_41_6 VSS VSS VDD VDD sky130_fd_sc_hd__decap_3
XFILLER_6_253 VSS VSS VDD VDD sky130_fd_sc_hd__decap_3
X_0660_ net132 regs\[21\]\[1\] net34 _0281_ regs\[15\]\[1\] VSS VSS VDD VDD _0354_
+ sky130_fd_sc_hd__a32o_1
X_0591_ net125 regs\[28\]\[0\] _0285_ VSS VSS VDD VDD _0286_ sky130_fd_sc_hd__and3_1
XFILLER_1_30 VSS VSS VDD VDD sky130_fd_sc_hd__decap_3
XFILLER_37_113 VSS VSS VDD VDD sky130_fd_sc_hd__decap_3
X_1212_ net112 _0066_ net77 VSS VSS VDD VDD regs\[6\]\[2\] sky130_fd_sc_hd__dfrtp_1
XFILLER_1_63 VSS VSS VDD VDD sky130_fd_sc_hd__decap_3
XFILLER_1_96 VSS VSS VDD VDD sky130_fd_sc_hd__decap_3
XFILLER_52_105 VSS VSS VDD VDD sky130_fd_sc_hd__fill_1
XFILLER_52_138 VSS VSS VDD VDD sky130_fd_sc_hd__fill_2
X_1143_ regs\[30\]\[5\] net163 _0275_ VSS VSS VDD VDD _0261_ sky130_fd_sc_hd__mux2_1
X_1074_ net130 net149 _0303_ VSS VSS VDD VDD _0268_ sky130_fd_sc_hd__and3_2
XTAP_TAPCELL_ROW_35_336 VSS VDD sky130_fd_sc_hd__tapvpwrvgnd_1
X_0927_ regs\[6\]\[5\] net160 _0560_ VSS VSS VDD VDD _0069_ sky130_fd_sc_hd__mux2_1
XTAP_TAPCELL_ROW_43_380 VSS VDD sky130_fd_sc_hd__tapvpwrvgnd_1
XFILLER_29_15 VSS VSS VDD VDD sky130_fd_sc_hd__decap_3
X_0858_ regs\[8\]\[7\] _0342_ _0543_ _0544_ _0545_ VSS VSS VDD VDD _0546_ sky130_fd_sc_hd__a2111o_1
X_0789_ net134 regs\[20\]\[5\] net28 VSS VSS VDD VDD _0479_ sky130_fd_sc_hd__and3_1
XFILLER_28_157 VSS VSS VDD VDD sky130_fd_sc_hd__decap_3
XFILLER_45_36 VSS VSS VDD VDD sky130_fd_sc_hd__decap_3
XFILLER_19_113 VSS VSS VDD VDD sky130_fd_sc_hd__fill_1
XTAP_TAPCELL_ROW_49_417 VSS VDD sky130_fd_sc_hd__tapvpwrvgnd_1
XFILLER_34_127 VSS VSS VDD VDD sky130_fd_sc_hd__decap_3
XTAP_TAPCELL_ROW_57_472 VSS VDD sky130_fd_sc_hd__tapvpwrvgnd_1
XFILLER_42_193 VSS VSS VDD VDD sky130_fd_sc_hd__decap_3
XTAP_TAPCELL_ROW_32_317 VSS VDD sky130_fd_sc_hd__tapvpwrvgnd_1
X_0712_ _0392_ _0397_ _0404_ VSS VSS VDD VDD _0405_ sky130_fd_sc_hd__or3_1
X_0643_ net123 _0300_ VSS VSS VDD VDD _0338_ sky130_fd_sc_hd__and2b_2
X_0574_ net128 net149 net38 VSS VSS VDD VDD _0277_ sky130_fd_sc_hd__and3_4
XFILLER_25_105 VSS VSS VDD VDD sky130_fd_sc_hd__decap_3
X_1126_ regs\[28\]\[6\] net158 _0273_ VSS VSS VDD VDD _0246_ sky130_fd_sc_hd__mux2_1
XFILLER_15_39 VSS VSS VDD VDD sky130_fd_sc_hd__decap_3
X_1057_ regs\[21\]\[0\] net44 _0266_ VSS VSS VDD VDD _0184_ sky130_fd_sc_hd__mux2_1
XFILLER_31_27 VSS VSS VDD VDD sky130_fd_sc_hd__decap_3
XFILLER_0_237 VSS VSS VDD VDD sky130_fd_sc_hd__decap_3
XFILLER_0_259 VSS VSS VDD VDD sky130_fd_sc_hd__decap_3
XFILLER_56_24 VSS VSS VDD VDD sky130_fd_sc_hd__decap_3
XFILLER_56_35 VSS VSS VDD VDD sky130_fd_sc_hd__decap_3
XFILLER_56_68 VSS VSS VDD VDD sky130_fd_sc_hd__decap_3
XFILLER_12_333 VSS VSS VDD VDD sky130_fd_sc_hd__decap_3
XFILLER_24_171 VSS VSS VDD VDD sky130_fd_sc_hd__decap_3
XFILLER_31_108 VSS VSS VDD VDD sky130_fd_sc_hd__decap_3
XFILLER_21_71 VSS VSS VDD VDD sky130_fd_sc_hd__decap_3
XFILLER_47_252 VSS VSS VDD VDD sky130_fd_sc_hd__decap_3
XFILLER_15_160 VSS VSS VDD VDD sky130_fd_sc_hd__decap_3
XFILLER_30_141 VSS VSS VDD VDD sky130_fd_sc_hd__decap_3
XFILLER_7_51 VSS VSS VDD VDD sky130_fd_sc_hd__decap_3
XFILLER_7_84 VSS VSS VDD VDD sky130_fd_sc_hd__decap_3
X_0626_ net122 regs\[27\]\[0\] _0306_ _0320_ regs\[20\]\[0\] VSS VSS VDD VDD _0321_
+ sky130_fd_sc_hd__a32o_1
XPHY_EDGE_ROW_15_Right_15 VSS VSS VDD VDD sky130_fd_sc_hd__decap_3
XFILLER_26_27 VSS VSS VDD VDD sky130_fd_sc_hd__fill_1
XFILLER_38_274 VSS VSS VDD VDD sky130_fd_sc_hd__decap_3
X_1109_ regs\[26\]\[7\] net152 _0271_ VSS VSS VDD VDD _0231_ sky130_fd_sc_hd__mux2_1
XPHY_EDGE_ROW_24_Right_24 VSS VSS VDD VDD sky130_fd_sc_hd__decap_3
XPHY_EDGE_ROW_33_Right_33 VSS VSS VDD VDD sky130_fd_sc_hd__decap_3
XFILLER_29_252 VSS VSS VDD VDD sky130_fd_sc_hd__decap_3
XFILLER_44_288 VSS VSS VDD VDD sky130_fd_sc_hd__fill_2
XFILLER_44_299 VSS VSS VDD VDD sky130_fd_sc_hd__decap_3
XPHY_EDGE_ROW_42_Right_42 VSS VSS VDD VDD sky130_fd_sc_hd__decap_3
XFILLER_32_81 VSS VSS VDD VDD sky130_fd_sc_hd__decap_3
XPHY_EDGE_ROW_51_Right_51 VSS VSS VDD VDD sky130_fd_sc_hd__decap_3
X_1391_ net86 _0245_ net51 VSS VSS VDD VDD regs\[28\]\[5\] sky130_fd_sc_hd__dfrtp_1
XFILLER_12_18 VSS VSS VDD VDD sky130_fd_sc_hd__decap_3
XFILLER_50_203 VSS VSS VDD VDD sky130_fd_sc_hd__decap_3
XFILLER_50_236 VSS VSS VDD VDD sky130_fd_sc_hd__decap_3
XFILLER_12_29 VSS VSS VDD VDD sky130_fd_sc_hd__decap_3
XFILLER_37_15 VSS VSS VDD VDD sky130_fd_sc_hd__decap_3
XFILLER_37_48 VSS VSS VDD VDD sky130_fd_sc_hd__decap_3
X_0609_ net119 _0303_ VSS VSS VDD VDD _0304_ sky130_fd_sc_hd__and2b_2
XFILLER_26_299 VSS VSS VDD VDD sky130_fd_sc_hd__decap_3
XFILLER_41_225 VSS VSS VDD VDD sky130_fd_sc_hd__decap_3
XFILLER_53_36 VSS VSS VDD VDD sky130_fd_sc_hd__decap_3
XFILLER_53_69 VSS VSS VDD VDD sky130_fd_sc_hd__decap_3
XFILLER_41_269 VSS VSS VDD VDD sky130_fd_sc_hd__fill_1
XFILLER_1_343 VSS VSS VDD VDD sky130_fd_sc_hd__fill_1
XFILLER_17_222 VSS VSS VDD VDD sky130_fd_sc_hd__fill_2
XFILLER_17_244 VSS VSS VDD VDD sky130_fd_sc_hd__decap_3
XTAP_TAPCELL_ROW_19_239 VSS VDD sky130_fd_sc_hd__tapvpwrvgnd_1
XFILLER_17_277 VSS VSS VDD VDD sky130_fd_sc_hd__decap_3
XFILLER_32_203 VSS VSS VDD VDD sky130_fd_sc_hd__decap_3
XFILLER_43_80 VSS VSS VDD VDD sky130_fd_sc_hd__decap_3
X_0960_ regs\[10\]\[2\] net172 _0564_ VSS VSS VDD VDD _0098_ sky130_fd_sc_hd__mux2_1
X_0891_ net160 regs\[2\]\[5\] _0556_ VSS VSS VDD VDD _0037_ sky130_fd_sc_hd__mux2_1
XTAP_TAPCELL_ROW_10_183 VSS VDD sky130_fd_sc_hd__tapvpwrvgnd_1
XFILLER_4_41 VSS VSS VDD VDD sky130_fd_sc_hd__decap_3
X_1374_ net99 _0228_ net64 VSS VSS VDD VDD regs\[26\]\[4\] sky130_fd_sc_hd__dfrtp_1
XFILLER_23_225 VSS VSS VDD VDD sky130_fd_sc_hd__fill_2
XFILLER_2_118 VSS VSS VDD VDD sky130_fd_sc_hd__fill_2
XFILLER_3_9 VSS VSS VDD VDD sky130_fd_sc_hd__decap_3
XFILLER_48_47 VSS VSS VDD VDD sky130_fd_sc_hd__decap_3
XFILLER_14_214 VSS VSS VDD VDD sky130_fd_sc_hd__decap_3
Xfanout73 net81 VSS VSS VDD VDD net73 sky130_fd_sc_hd__clkbuf_4
Xfanout62 net64 VSS VSS VDD VDD net62 sky130_fd_sc_hd__clkbuf_4
Xfanout51 net55 VSS VSS VDD VDD net51 sky130_fd_sc_hd__clkbuf_4
Xfanout40 net41 VSS VSS VDD VDD net40 sky130_fd_sc_hd__buf_2
XFILLER_13_94 VSS VSS VDD VDD sky130_fd_sc_hd__decap_3
XFILLER_22_291 VSS VSS VDD VDD sky130_fd_sc_hd__decap_3
Xfanout95 net99 VSS VSS VDD VDD net95 sky130_fd_sc_hd__clkbuf_2
Xfanout84 net85 VSS VSS VDD VDD net84 sky130_fd_sc_hd__dlymetal6s2s_1
XFILLER_36_9 VSS VSS VDD VDD sky130_fd_sc_hd__decap_3
XFILLER_49_155 VSS VSS VDD VDD sky130_fd_sc_hd__fill_1
XFILLER_49_166 VSS VSS VDD VDD sky130_fd_sc_hd__fill_2
XFILLER_38_80 VSS VSS VDD VDD sky130_fd_sc_hd__decap_3
XFILLER_38_91 VSS VSS VDD VDD sky130_fd_sc_hd__decap_3
XFILLER_52_309 VSS VSS VDD VDD sky130_fd_sc_hd__fill_2
X_1090_ regs\[24\]\[6\] net156 _0269_ VSS VSS VDD VDD _0214_ sky130_fd_sc_hd__mux2_1
XFILLER_20_228 VSS VSS VDD VDD sky130_fd_sc_hd__fill_1
X_0943_ net170 regs\[8\]\[3\] _0562_ VSS VSS VDD VDD _0083_ sky130_fd_sc_hd__mux2_1
X_0874_ net156 regs\[0\]\[6\] _0554_ VSS VSS VDD VDD _0022_ sky130_fd_sc_hd__mux2_1
XFILLER_28_328 VSS VSS VDD VDD sky130_fd_sc_hd__fill_2
XFILLER_28_339 VSS VSS VDD VDD sky130_fd_sc_hd__fill_1
X_1288_ net111 _0142_ net76 VSS VSS VDD VDD regs\[15\]\[6\] sky130_fd_sc_hd__dfrtp_1
X_1357_ net106 _0211_ net71 VSS VSS VDD VDD regs\[24\]\[3\] sky130_fd_sc_hd__dfrtp_1
XFILLER_11_206 VSS VSS VDD VDD sky130_fd_sc_hd__decap_3
XFILLER_11_228 VSS VSS VDD VDD sky130_fd_sc_hd__decap_3
XFILLER_34_27 VSS VSS VDD VDD sky130_fd_sc_hd__fill_1
XFILLER_51_320 VSS VSS VDD VDD sky130_fd_sc_hd__decap_3
XFILLER_55_169 VSS VSS VDD VDD sky130_fd_sc_hd__fill_2
XFILLER_50_15 VSS VSS VDD VDD sky130_fd_sc_hd__decap_3
XFILLER_50_59 VSS VSS VDD VDD sky130_fd_sc_hd__decap_3
XFILLER_1_6 VSS VSS VDD VDD sky130_fd_sc_hd__decap_3
XFILLER_46_147 VSS VSS VDD VDD sky130_fd_sc_hd__decap_3
XTAP_TAPCELL_ROW_29_301 VSS VDD sky130_fd_sc_hd__tapvpwrvgnd_1
XFILLER_40_81 VSS VSS VDD VDD sky130_fd_sc_hd__decap_3
XFILLER_6_232 VSS VSS VDD VDD sky130_fd_sc_hd__decap_3
X_0590_ net143 net175 net141 net139 VSS VSS VDD VDD _0285_ sky130_fd_sc_hd__and4bb_2
XFILLER_1_42 VSS VSS VDD VDD sky130_fd_sc_hd__decap_3
XFILLER_34_6 VSS VSS VDD VDD sky130_fd_sc_hd__decap_3
X_1211_ net95 _0065_ net60 VSS VSS VDD VDD regs\[6\]\[1\] sky130_fd_sc_hd__dfrtp_1
X_1142_ regs\[30\]\[4\] net167 _0275_ VSS VSS VDD VDD _0260_ sky130_fd_sc_hd__mux2_1
XFILLER_1_75 VSS VSS VDD VDD sky130_fd_sc_hd__decap_3
XFILLER_33_342 VSS VSS VDD VDD sky130_fd_sc_hd__fill_2
X_1073_ regs\[22\]\[7\] net155 _0267_ VSS VSS VDD VDD _0199_ sky130_fd_sc_hd__mux2_1
XTAP_TAPCELL_ROW_35_337 VSS VDD sky130_fd_sc_hd__tapvpwrvgnd_1
XFILLER_20_18 VSS VSS VDD VDD sky130_fd_sc_hd__decap_3
XFILLER_20_29 VSS VSS VDD VDD sky130_fd_sc_hd__fill_2
X_0926_ regs\[6\]\[4\] net166 _0560_ VSS VSS VDD VDD _0068_ sky130_fd_sc_hd__mux2_1
X_0857_ net120 regs\[11\]\[7\] net31 VSS VSS VDD VDD _0545_ sky130_fd_sc_hd__and3b_1
XTAP_TAPCELL_ROW_43_381 VSS VDD sky130_fd_sc_hd__tapvpwrvgnd_1
XFILLER_29_27 VSS VSS VDD VDD sky130_fd_sc_hd__decap_3
X_1409_ net105 _0263_ net70 VSS VSS VDD VDD regs\[30\]\[7\] sky130_fd_sc_hd__dfrtp_1
X_0788_ net136 regs\[22\]\[5\] net32 VSS VSS VDD VDD _0478_ sky130_fd_sc_hd__and3_1
XFILLER_28_103 VSS VSS VDD VDD sky130_fd_sc_hd__decap_3
XFILLER_28_136 VSS VSS VDD VDD sky130_fd_sc_hd__decap_3
XFILLER_45_15 VSS VSS VDD VDD sky130_fd_sc_hd__decap_3
XFILLER_45_48 VSS VSS VDD VDD sky130_fd_sc_hd__decap_3
XFILLER_51_150 VSS VSS VDD VDD sky130_fd_sc_hd__fill_1
XFILLER_3_257 VSS VSS VDD VDD sky130_fd_sc_hd__decap_3
XFILLER_19_82 VSS VSS VDD VDD sky130_fd_sc_hd__decap_3
XTAP_TAPCELL_ROW_49_418 VSS VDD sky130_fd_sc_hd__tapvpwrvgnd_1
XFILLER_15_320 VSS VSS VDD VDD sky130_fd_sc_hd__decap_3
XFILLER_34_106 VSS VSS VDD VDD sky130_fd_sc_hd__decap_3
XFILLER_34_139 VSS VSS VDD VDD sky130_fd_sc_hd__fill_1
XFILLER_35_81 VSS VSS VDD VDD sky130_fd_sc_hd__fill_2
XFILLER_42_150 VSS VSS VDD VDD sky130_fd_sc_hd__decap_3
XTAP_TAPCELL_ROW_57_473 VSS VDD sky130_fd_sc_hd__tapvpwrvgnd_1
XTAP_TAPCELL_ROW_32_318 VSS VDD sky130_fd_sc_hd__tapvpwrvgnd_1
X_0711_ _0401_ _0402_ _0403_ VSS VSS VDD VDD _0404_ sky130_fd_sc_hd__or3_1
XTAP_TAPCELL_ROW_40_362 VSS VDD sky130_fd_sc_hd__tapvpwrvgnd_1
XFILLER_32_3 VSS VSS VDD VDD sky130_fd_sc_hd__decap_3
X_0642_ regs\[12\]\[0\] _0335_ _0336_ regs\[2\]\[0\] VSS VSS VDD VDD _0337_ sky130_fd_sc_hd__a22o_1
X_0573_ net143 net175 net141 net139 VSS VSS VDD VDD _0276_ sky130_fd_sc_hd__and4_1
XFILLER_57_209 VSS VSS VDD VDD sky130_fd_sc_hd__decap_3
X_1125_ regs\[28\]\[5\] net161 _0273_ VSS VSS VDD VDD _0245_ sky130_fd_sc_hd__mux2_1
XFILLER_15_18 VSS VSS VDD VDD sky130_fd_sc_hd__decap_3
XFILLER_18_191 VSS VSS VDD VDD sky130_fd_sc_hd__decap_3
XFILLER_33_161 VSS VSS VDD VDD sky130_fd_sc_hd__decap_3
XFILLER_33_172 VSS VSS VDD VDD sky130_fd_sc_hd__decap_3
X_1056_ net130 net149 net34 VSS VSS VDD VDD _0266_ sky130_fd_sc_hd__and3_4
Xoutput17 net17 VSS VSS VDD VDD rdata[0] sky130_fd_sc_hd__buf_2
X_0909_ net162 regs\[4\]\[5\] _0558_ VSS VSS VDD VDD _0053_ sky130_fd_sc_hd__mux2_1
XFILLER_0_216 VSS VSS VDD VDD sky130_fd_sc_hd__decap_3
XFILLER_56_47 VSS VSS VDD VDD sky130_fd_sc_hd__decap_3
XFILLER_24_150 VSS VSS VDD VDD sky130_fd_sc_hd__decap_3
XFILLER_24_194 VSS VSS VDD VDD sky130_fd_sc_hd__fill_2
XFILLER_8_305 VSS VSS VDD VDD sky130_fd_sc_hd__decap_3
XFILLER_21_94 VSS VSS VDD VDD sky130_fd_sc_hd__decap_3
XFILLER_39_209 VSS VSS VDD VDD sky130_fd_sc_hd__decap_3
XFILLER_47_275 VSS VSS VDD VDD sky130_fd_sc_hd__decap_3
XFILLER_30_153 VSS VSS VDD VDD sky130_fd_sc_hd__decap_3
XFILLER_46_80 VSS VSS VDD VDD sky130_fd_sc_hd__decap_3
XFILLER_7_30 VSS VSS VDD VDD sky130_fd_sc_hd__decap_3
XFILLER_7_96 VSS VSS VDD VDD sky130_fd_sc_hd__decap_3
X_0625_ net133 _0319_ VSS VSS VDD VDD _0320_ sky130_fd_sc_hd__and2_2
XFILLER_38_286 VSS VSS VDD VDD sky130_fd_sc_hd__decap_3
XFILLER_53_212 VSS VSS VDD VDD sky130_fd_sc_hd__decap_3
XFILLER_53_234 VSS VSS VDD VDD sky130_fd_sc_hd__decap_3
XFILLER_53_245 VSS VSS VDD VDD sky130_fd_sc_hd__decap_3
X_1108_ regs\[26\]\[6\] net156 _0271_ VSS VSS VDD VDD _0230_ sky130_fd_sc_hd__mux2_1
X_1039_ regs\[19\]\[0\] net43 _0264_ VSS VSS VDD VDD _0168_ sky130_fd_sc_hd__mux2_1
XFILLER_21_153 VSS VSS VDD VDD sky130_fd_sc_hd__decap_3
XFILLER_42_16 VSS VSS VDD VDD sky130_fd_sc_hd__decap_3
XFILLER_42_38 VSS VSS VDD VDD sky130_fd_sc_hd__decap_3
XFILLER_29_231 VSS VSS VDD VDD sky130_fd_sc_hd__fill_2
XFILLER_29_264 VSS VSS VDD VDD sky130_fd_sc_hd__fill_2
XFILLER_29_275 VSS VSS VDD VDD sky130_fd_sc_hd__decap_3
XPHY_EDGE_ROW_48_Left_106 VSS VSS VDD VDD sky130_fd_sc_hd__decap_3
XFILLER_8_124 VSS VSS VDD VDD sky130_fd_sc_hd__decap_3
XPHY_EDGE_ROW_57_Left_115 VSS VSS VDD VDD sky130_fd_sc_hd__decap_3
X_1390_ net100 _0244_ net65 VSS VSS VDD VDD regs\[28\]\[4\] sky130_fd_sc_hd__dfrtp_1
XFILLER_35_201 VSS VSS VDD VDD sky130_fd_sc_hd__decap_3
XFILLER_35_234 VSS VSS VDD VDD sky130_fd_sc_hd__decap_3
XFILLER_35_267 VSS VSS VDD VDD sky130_fd_sc_hd__decap_3
XFILLER_50_215 VSS VSS VDD VDD sky130_fd_sc_hd__decap_3
X_0608_ net140 net142 net176 net144 VSS VSS VDD VDD _0303_ sky130_fd_sc_hd__and4b_2
XFILLER_26_212 VSS VSS VDD VDD sky130_fd_sc_hd__decap_3
XFILLER_37_27 VSS VSS VDD VDD sky130_fd_sc_hd__decap_3
XFILLER_26_256 VSS VSS VDD VDD sky130_fd_sc_hd__decap_3
XFILLER_26_278 VSS VSS VDD VDD sky130_fd_sc_hd__fill_1
XFILLER_53_15 VSS VSS VDD VDD sky130_fd_sc_hd__decap_3
XFILLER_53_48 VSS VSS VDD VDD sky130_fd_sc_hd__decap_3
XFILLER_5_105 VSS VSS VDD VDD sky130_fd_sc_hd__fill_1
XFILLER_49_315 VSS VSS VDD VDD sky130_fd_sc_hd__decap_3
XFILLER_17_256 VSS VSS VDD VDD sky130_fd_sc_hd__decap_3
X_0890_ net164 regs\[2\]\[4\] _0556_ VSS VSS VDD VDD _0036_ sky130_fd_sc_hd__mux2_1
XTAP_TAPCELL_ROW_27_284 VSS VDD sky130_fd_sc_hd__tapvpwrvgnd_1
XFILLER_4_182 VSS VSS VDD VDD sky130_fd_sc_hd__decap_3
XTAP_TAPCELL_ROW_10_184 VSS VDD sky130_fd_sc_hd__tapvpwrvgnd_1
XFILLER_4_53 VSS VSS VDD VDD sky130_fd_sc_hd__decap_3
X_1373_ net95 _0227_ net60 VSS VSS VDD VDD regs\[26\]\[3\] sky130_fd_sc_hd__dfrtp_1
XFILLER_23_18 VSS VSS VDD VDD sky130_fd_sc_hd__decap_3
XFILLER_31_281 VSS VSS VDD VDD sky130_fd_sc_hd__decap_3
XFILLER_48_15 VSS VSS VDD VDD sky130_fd_sc_hd__decap_3
XFILLER_46_318 VSS VSS VDD VDD sky130_fd_sc_hd__decap_3
XFILLER_48_59 VSS VSS VDD VDD sky130_fd_sc_hd__decap_3
XTAP_TAPCELL_ROW_1_130 VSS VDD sky130_fd_sc_hd__tapvpwrvgnd_1
XFILLER_14_226 VSS VSS VDD VDD sky130_fd_sc_hd__decap_3
XFILLER_14_248 VSS VSS VDD VDD sky130_fd_sc_hd__decap_3
Xfanout30 _0312_ VSS VSS VDD VDD net30 sky130_fd_sc_hd__buf_2
Xfanout96 net99 VSS VSS VDD VDD net96 sky130_fd_sc_hd__dlymetal6s2s_1
Xfanout85 net90 VSS VSS VDD VDD net85 sky130_fd_sc_hd__buf_1
Xfanout74 net81 VSS VSS VDD VDD net74 sky130_fd_sc_hd__buf_2
Xfanout63 net64 VSS VSS VDD VDD net63 sky130_fd_sc_hd__buf_2
Xfanout52 net55 VSS VSS VDD VDD net52 sky130_fd_sc_hd__clkbuf_4
Xfanout41 net42 VSS VSS VDD VDD net41 sky130_fd_sc_hd__clkbuf_4
XFILLER_29_9 VSS VSS VDD VDD sky130_fd_sc_hd__decap_3
XFILLER_49_123 VSS VSS VDD VDD sky130_fd_sc_hd__fill_2
XFILLER_45_340 VSS VSS VDD VDD sky130_fd_sc_hd__decap_3
XFILLER_54_80 VSS VSS VDD VDD sky130_fd_sc_hd__decap_3
X_0942_ net173 regs\[8\]\[2\] _0562_ VSS VSS VDD VDD _0082_ sky130_fd_sc_hd__mux2_1
X_0873_ net160 regs\[0\]\[5\] _0554_ VSS VSS VDD VDD _0021_ sky130_fd_sc_hd__mux2_1
XFILLER_9_252 VSS VSS VDD VDD sky130_fd_sc_hd__decap_3
XFILLER_18_18 VSS VSS VDD VDD sky130_fd_sc_hd__decap_3
XFILLER_18_29 VSS VSS VDD VDD sky130_fd_sc_hd__decap_3
XFILLER_55_104 VSS VSS VDD VDD sky130_fd_sc_hd__decap_3
X_1287_ net115 _0141_ net80 VSS VSS VDD VDD regs\[15\]\[5\] sky130_fd_sc_hd__dfrtp_1
X_1356_ net101 _0210_ net66 VSS VSS VDD VDD regs\[24\]\[2\] sky130_fd_sc_hd__dfrtp_1
XFILLER_50_27 VSS VSS VDD VDD sky130_fd_sc_hd__fill_1
XFILLER_50_38 VSS VSS VDD VDD sky130_fd_sc_hd__decap_3
XFILLER_19_307 VSS VSS VDD VDD sky130_fd_sc_hd__decap_3
XFILLER_27_340 VSS VSS VDD VDD sky130_fd_sc_hd__decap_3
XFILLER_42_321 VSS VSS VDD VDD sky130_fd_sc_hd__decap_3
XFILLER_10_251 VSS VSS VDD VDD sky130_fd_sc_hd__fill_1
XFILLER_10_284 VSS VSS VDD VDD sky130_fd_sc_hd__decap_3
XFILLER_24_50 VSS VSS VDD VDD sky130_fd_sc_hd__fill_2
XFILLER_24_61 VSS VSS VDD VDD sky130_fd_sc_hd__decap_3
XFILLER_24_83 VSS VSS VDD VDD sky130_fd_sc_hd__fill_1
XFILLER_24_94 VSS VSS VDD VDD sky130_fd_sc_hd__decap_3
XFILLER_6_200 VSS VSS VDD VDD sky130_fd_sc_hd__fill_2
XFILLER_6_222 VSS VSS VDD VDD sky130_fd_sc_hd__fill_2
XFILLER_6_244 VSS VSS VDD VDD sky130_fd_sc_hd__decap_3
XFILLER_6_288 VSS VSS VDD VDD sky130_fd_sc_hd__decap_3
XFILLER_1_21 VSS VSS VDD VDD sky130_fd_sc_hd__decap_3
XFILLER_1_54 VSS VSS VDD VDD sky130_fd_sc_hd__fill_2
XFILLER_1_87 VSS VSS VDD VDD sky130_fd_sc_hd__decap_3
XFILLER_27_6 VSS VSS VDD VDD sky130_fd_sc_hd__decap_3
XFILLER_37_137 VSS VSS VDD VDD sky130_fd_sc_hd__decap_3
X_1210_ net110 _0064_ net75 VSS VSS VDD VDD regs\[6\]\[0\] sky130_fd_sc_hd__dfrtp_1
X_1141_ regs\[30\]\[3\] net171 _0275_ VSS VSS VDD VDD _0259_ sky130_fd_sc_hd__mux2_1
X_1072_ regs\[22\]\[6\] net159 _0267_ VSS VSS VDD VDD _0198_ sky130_fd_sc_hd__mux2_1
XTAP_TAPCELL_ROW_43_382 VSS VDD sky130_fd_sc_hd__tapvpwrvgnd_1
X_0925_ regs\[6\]\[3\] net170 _0560_ VSS VSS VDD VDD _0067_ sky130_fd_sc_hd__mux2_1
X_0856_ net118 regs\[24\]\[7\] net25 VSS VSS VDD VDD _0544_ sky130_fd_sc_hd__and3_1
X_0787_ _0471_ _0472_ _0476_ VSS VSS VDD VDD _0477_ sky130_fd_sc_hd__or3_1
XFILLER_29_39 VSS VSS VDD VDD sky130_fd_sc_hd__decap_3
X_1408_ net97 _0262_ net62 VSS VSS VDD VDD regs\[30\]\[6\] sky130_fd_sc_hd__dfrtp_1
XFILLER_36_192 VSS VSS VDD VDD sky130_fd_sc_hd__decap_3
XFILLER_45_27 VSS VSS VDD VDD sky130_fd_sc_hd__decap_3
X_1339_ net112 _0193_ net77 VSS VSS VDD VDD regs\[22\]\[1\] sky130_fd_sc_hd__dfrtp_1
XFILLER_51_173 VSS VSS VDD VDD sky130_fd_sc_hd__decap_3
XFILLER_10_41 VSS VSS VDD VDD sky130_fd_sc_hd__fill_1
XFILLER_10_85 VSS VSS VDD VDD sky130_fd_sc_hd__fill_1
XFILLER_19_104 VSS VSS VDD VDD sky130_fd_sc_hd__decap_3
XTAP_TAPCELL_ROW_49_419 VSS VDD sky130_fd_sc_hd__tapvpwrvgnd_1
XFILLER_15_343 VSS VSS VDD VDD sky130_fd_sc_hd__fill_1
XFILLER_30_335 VSS VSS VDD VDD sky130_fd_sc_hd__decap_3
XFILLER_34_118 VSS VSS VDD VDD sky130_fd_sc_hd__decap_3
XFILLER_35_60 VSS VSS VDD VDD sky130_fd_sc_hd__decap_3
XFILLER_42_173 VSS VSS VDD VDD sky130_fd_sc_hd__decap_3
XFILLER_42_184 VSS VSS VDD VDD sky130_fd_sc_hd__decap_3
XTAP_TAPCELL_ROW_57_474 VSS VDD sky130_fd_sc_hd__tapvpwrvgnd_1
XTAP_TAPCELL_ROW_32_319 VSS VDD sky130_fd_sc_hd__tapvpwrvgnd_1
XFILLER_51_81 VSS VSS VDD VDD sky130_fd_sc_hd__fill_2
XFILLER_51_92 VSS VSS VDD VDD sky130_fd_sc_hd__decap_3
X_0710_ regs\[7\]\[2\] _0304_ _0342_ regs\[8\]\[2\] VSS VSS VDD VDD _0403_ sky130_fd_sc_hd__a22o_1
X_0641_ net124 _0288_ VSS VSS VDD VDD _0336_ sky130_fd_sc_hd__and2b_4
XTAP_TAPCELL_ROW_40_363 VSS VDD sky130_fd_sc_hd__tapvpwrvgnd_1
XFILLER_25_3 VSS VSS VDD VDD sky130_fd_sc_hd__decap_3
XPHY_EDGE_ROW_27_Left_85 VSS VSS VDD VDD sky130_fd_sc_hd__decap_3
X_1124_ regs\[28\]\[4\] net167 _0273_ VSS VSS VDD VDD _0244_ sky130_fd_sc_hd__mux2_1
X_1055_ regs\[20\]\[7\] net155 _0265_ VSS VSS VDD VDD _0183_ sky130_fd_sc_hd__mux2_1
XPHY_EDGE_ROW_11_Left_69 VSS VSS VDD VDD sky130_fd_sc_hd__decap_3
XFILLER_31_18 VSS VSS VDD VDD sky130_fd_sc_hd__decap_3
XFILLER_33_140 VSS VSS VDD VDD sky130_fd_sc_hd__decap_3
XFILLER_0_228 VSS VSS VDD VDD sky130_fd_sc_hd__decap_3
Xoutput18 net18 VSS VSS VDD VDD rdata[1] sky130_fd_sc_hd__buf_2
X_0908_ net166 regs\[4\]\[4\] _0558_ VSS VSS VDD VDD _0052_ sky130_fd_sc_hd__mux2_1
X_0839_ regs\[1\]\[7\] _0299_ _0316_ regs\[9\]\[7\] VSS VSS VDD VDD _0527_ sky130_fd_sc_hd__a22o_1
XFILLER_56_15 VSS VSS VDD VDD sky130_fd_sc_hd__decap_3
XFILLER_56_59 VSS VSS VDD VDD sky130_fd_sc_hd__decap_3
XFILLER_24_162 VSS VSS VDD VDD sky130_fd_sc_hd__decap_3
XFILLER_21_51 VSS VSS VDD VDD sky130_fd_sc_hd__decap_3
XFILLER_11_9 VSS VSS VDD VDD sky130_fd_sc_hd__decap_3
XFILLER_30_110 VSS VSS VDD VDD sky130_fd_sc_hd__decap_3
XFILLER_30_165 VSS VSS VDD VDD sky130_fd_sc_hd__decap_3
XFILLER_7_42 VSS VSS VDD VDD sky130_fd_sc_hd__decap_3
XFILLER_7_75 VSS VSS VDD VDD sky130_fd_sc_hd__decap_3
X_0624_ net144 net176 net140 net142 VSS VSS VDD VDD _0319_ sky130_fd_sc_hd__nor4b_1
XFILLER_38_243 VSS VSS VDD VDD sky130_fd_sc_hd__decap_3
XFILLER_26_18 VSS VSS VDD VDD sky130_fd_sc_hd__decap_3
XFILLER_26_29 VSS VSS VDD VDD sky130_fd_sc_hd__decap_3
XFILLER_38_265 VSS VSS VDD VDD sky130_fd_sc_hd__decap_3
X_1107_ regs\[26\]\[5\] net160 _0271_ VSS VSS VDD VDD _0229_ sky130_fd_sc_hd__mux2_1
X_1038_ net130 net149 _0283_ VSS VSS VDD VDD _0264_ sky130_fd_sc_hd__and3_4
XPHY_EDGE_ROW_5_Right_5 VSS VSS VDD VDD sky130_fd_sc_hd__decap_3
XFILLER_29_243 VSS VSS VDD VDD sky130_fd_sc_hd__decap_3
XFILLER_12_132 VSS VSS VDD VDD sky130_fd_sc_hd__decap_3
XFILLER_16_73 VSS VSS VDD VDD sky130_fd_sc_hd__fill_2
XFILLER_16_95 VSS VSS VDD VDD sky130_fd_sc_hd__decap_3
XFILLER_44_279 VSS VSS VDD VDD sky130_fd_sc_hd__decap_3
XFILLER_8_136 VSS VSS VDD VDD sky130_fd_sc_hd__decap_3
XFILLER_8_147 VSS VSS VDD VDD sky130_fd_sc_hd__decap_3
XFILLER_35_279 VSS VSS VDD VDD sky130_fd_sc_hd__fill_1
XFILLER_50_227 VSS VSS VDD VDD sky130_fd_sc_hd__decap_3
XFILLER_57_91 VSS VSS VDD VDD sky130_fd_sc_hd__decap_3
XFILLER_7_191 VSS VSS VDD VDD sky130_fd_sc_hd__decap_3
X_0607_ net119 regs\[26\]\[0\] _0300_ VSS VSS VDD VDD _0302_ sky130_fd_sc_hd__and3_1
XFILLER_26_235 VSS VSS VDD VDD sky130_fd_sc_hd__decap_3
XFILLER_37_39 VSS VSS VDD VDD sky130_fd_sc_hd__decap_3
XFILLER_26_268 VSS VSS VDD VDD sky130_fd_sc_hd__fill_1
XFILLER_53_27 VSS VSS VDD VDD sky130_fd_sc_hd__decap_3
XPHY_EDGE_ROW_14_Left_72 VSS VSS VDD VDD sky130_fd_sc_hd__decap_3
XTAP_TAPCELL_ROW_4_150 VSS VDD sky130_fd_sc_hd__tapvpwrvgnd_1
XFILLER_17_268 VSS VSS VDD VDD sky130_fd_sc_hd__decap_3
XFILLER_32_216 VSS VSS VDD VDD sky130_fd_sc_hd__decap_3
XTAP_TAPCELL_ROW_27_285 VSS VDD sky130_fd_sc_hd__tapvpwrvgnd_1
XFILLER_32_249 VSS VSS VDD VDD sky130_fd_sc_hd__decap_3
XFILLER_4_194 VSS VSS VDD VDD sky130_fd_sc_hd__fill_2
XFILLER_4_21 VSS VSS VDD VDD sky130_fd_sc_hd__decap_3
XFILLER_4_32 VSS VSS VDD VDD sky130_fd_sc_hd__decap_3
XFILLER_57_6 VSS VSS VDD VDD sky130_fd_sc_hd__decap_3
XTAP_TAPCELL_ROW_10_185 VSS VDD sky130_fd_sc_hd__tapvpwrvgnd_1
X_1372_ net95 _0226_ net60 VSS VSS VDD VDD regs\[26\]\[2\] sky130_fd_sc_hd__dfrtp_1
XTAP_TAPCELL_ROW_18_230 VSS VDD sky130_fd_sc_hd__tapvpwrvgnd_1
XFILLER_2_109 VSS VSS VDD VDD sky130_fd_sc_hd__decap_3
XFILLER_48_27 VSS VSS VDD VDD sky130_fd_sc_hd__fill_1
XFILLER_48_38 VSS VSS VDD VDD sky130_fd_sc_hd__decap_3
XFILLER_54_330 VSS VSS VDD VDD sky130_fd_sc_hd__decap_3
XTAP_TAPCELL_ROW_1_131 VSS VDD sky130_fd_sc_hd__tapvpwrvgnd_1
XFILLER_13_30 VSS VSS VDD VDD sky130_fd_sc_hd__decap_3
XFILLER_13_52 VSS VSS VDD VDD sky130_fd_sc_hd__decap_3
Xfanout97 net99 VSS VSS VDD VDD net97 sky130_fd_sc_hd__clkbuf_2
Xfanout86 net90 VSS VSS VDD VDD net86 sky130_fd_sc_hd__clkbuf_2
Xfanout75 net81 VSS VSS VDD VDD net75 sky130_fd_sc_hd__clkbuf_4
Xfanout64 net7 VSS VSS VDD VDD net64 sky130_fd_sc_hd__buf_2
Xfanout53 net55 VSS VSS VDD VDD net53 sky130_fd_sc_hd__clkbuf_4
Xfanout42 net9 VSS VSS VDD VDD net42 sky130_fd_sc_hd__buf_2
Xfanout31 _0306_ VSS VSS VDD VDD net31 sky130_fd_sc_hd__clkbuf_4
XTAP_TAPCELL_ROW_24_266 VSS VDD sky130_fd_sc_hd__tapvpwrvgnd_1
XFILLER_38_71 VSS VSS VDD VDD sky130_fd_sc_hd__decap_3
XFILLER_49_102 VSS VSS VDD VDD sky130_fd_sc_hd__fill_1
X_0941_ net41 regs\[8\]\[1\] _0562_ VSS VSS VDD VDD _0081_ sky130_fd_sc_hd__mux2_1
XFILLER_13_271 VSS VSS VDD VDD sky130_fd_sc_hd__decap_3
XFILLER_55_3 VSS VSS VDD VDD sky130_fd_sc_hd__decap_3
X_0872_ net164 regs\[0\]\[4\] _0554_ VSS VSS VDD VDD _0020_ sky130_fd_sc_hd__mux2_1
X_1355_ net101 _0209_ net66 VSS VSS VDD VDD regs\[24\]\[1\] sky130_fd_sc_hd__dfrtp_1
XFILLER_34_18 VSS VSS VDD VDD sky130_fd_sc_hd__decap_3
XFILLER_51_311 VSS VSS VDD VDD sky130_fd_sc_hd__decap_3
XFILLER_55_116 VSS VSS VDD VDD sky130_fd_sc_hd__decap_3
X_1286_ net111 _0140_ net76 VSS VSS VDD VDD regs\[15\]\[4\] sky130_fd_sc_hd__dfrtp_1
XFILLER_11_219 VSS VSS VDD VDD sky130_fd_sc_hd__decap_3
XFILLER_34_29 VSS VSS VDD VDD sky130_fd_sc_hd__decap_3
XPHY_EDGE_ROW_41_Left_99 VSS VSS VDD VDD sky130_fd_sc_hd__decap_3
XFILLER_39_190 VSS VSS VDD VDD sky130_fd_sc_hd__decap_3
XFILLER_41_9 VSS VSS VDD VDD sky130_fd_sc_hd__decap_3
XFILLER_1_33 VSS VSS VDD VDD sky130_fd_sc_hd__decap_3
XFILLER_1_66 VSS VSS VDD VDD sky130_fd_sc_hd__decap_3
XFILLER_1_99 VSS VSS VDD VDD sky130_fd_sc_hd__decap_3
XFILLER_37_116 VSS VSS VDD VDD sky130_fd_sc_hd__decap_3
XFILLER_45_160 VSS VSS VDD VDD sky130_fd_sc_hd__decap_3
X_1140_ regs\[30\]\[2\] net173 _0275_ VSS VSS VDD VDD _0258_ sky130_fd_sc_hd__mux2_1
X_1071_ regs\[22\]\[5\] net163 _0267_ VSS VSS VDD VDD _0197_ sky130_fd_sc_hd__mux2_1
X_0924_ regs\[6\]\[2\] net172 _0560_ VSS VSS VDD VDD _0066_ sky130_fd_sc_hd__mux2_1
XTAP_TAPCELL_ROW_43_383 VSS VDD sky130_fd_sc_hd__tapvpwrvgnd_1
X_0855_ net118 regs\[28\]\[7\] net36 VSS VSS VDD VDD _0543_ sky130_fd_sc_hd__and3_1
X_0786_ regs\[8\]\[5\] _0342_ _0473_ _0474_ _0475_ VSS VSS VDD VDD _0476_ sky130_fd_sc_hd__a2111o_1
XFILLER_29_18 VSS VSS VDD VDD sky130_fd_sc_hd__decap_3
X_1338_ net108 _0192_ net73 VSS VSS VDD VDD regs\[22\]\[0\] sky130_fd_sc_hd__dfrtp_1
X_1407_ net113 _0261_ net78 VSS VSS VDD VDD regs\[30\]\[5\] sky130_fd_sc_hd__dfrtp_1
XFILLER_45_39 VSS VSS VDD VDD sky130_fd_sc_hd__decap_3
XFILLER_51_141 VSS VSS VDD VDD sky130_fd_sc_hd__decap_3
X_1269_ net86 _0123_ net51 VSS VSS VDD VDD regs\[13\]\[3\] sky130_fd_sc_hd__dfrtp_1
XFILLER_3_215 VSS VSS VDD VDD sky130_fd_sc_hd__decap_3
XFILLER_19_73 VSS VSS VDD VDD sky130_fd_sc_hd__decap_3
XTAP_TAPCELL_ROW_57_475 VSS VDD sky130_fd_sc_hd__tapvpwrvgnd_1
XTAP_TAPCELL_ROW_57_464 VSS VDD sky130_fd_sc_hd__tapvpwrvgnd_1
XFILLER_27_182 VSS VSS VDD VDD sky130_fd_sc_hd__fill_1
XFILLER_35_72 VSS VSS VDD VDD sky130_fd_sc_hd__decap_3
XFILLER_42_141 VSS VSS VDD VDD sky130_fd_sc_hd__decap_3
XFILLER_51_60 VSS VSS VDD VDD sky130_fd_sc_hd__decap_3
X_0640_ net126 net36 VSS VSS VDD VDD _0335_ sky130_fd_sc_hd__and2b_2
XTAP_TAPCELL_ROW_40_364 VSS VDD sky130_fd_sc_hd__tapvpwrvgnd_1
XPHY_EDGE_ROW_2_Left_60 VSS VSS VDD VDD sky130_fd_sc_hd__decap_3
XFILLER_18_3 VSS VSS VDD VDD sky130_fd_sc_hd__decap_3
XFILLER_25_108 VSS VSS VDD VDD sky130_fd_sc_hd__decap_3
X_1123_ regs\[28\]\[3\] net168 _0273_ VSS VSS VDD VDD _0243_ sky130_fd_sc_hd__mux2_1
X_1054_ regs\[20\]\[6\] net157 _0265_ VSS VSS VDD VDD _0182_ sky130_fd_sc_hd__mux2_1
X_0907_ net168 regs\[4\]\[3\] _0558_ VSS VSS VDD VDD _0051_ sky130_fd_sc_hd__mux2_1
Xoutput19 net19 VSS VSS VDD VDD rdata[2] sky130_fd_sc_hd__buf_2
X_0838_ regs\[13\]\[7\] _0313_ _0335_ regs\[12\]\[7\] VSS VSS VDD VDD _0526_ sky130_fd_sc_hd__a22o_1
X_0769_ regs\[17\]\[4\] _0279_ _0284_ regs\[3\]\[4\] VSS VSS VDD VDD _0460_ sky130_fd_sc_hd__a22o_1
XFILLER_56_27 VSS VSS VDD VDD sky130_fd_sc_hd__fill_1
XFILLER_56_38 VSS VSS VDD VDD sky130_fd_sc_hd__decap_3
XFILLER_12_303 VSS VSS VDD VDD sky130_fd_sc_hd__decap_3
XFILLER_12_336 VSS VSS VDD VDD sky130_fd_sc_hd__decap_3
XFILLER_24_141 VSS VSS VDD VDD sky130_fd_sc_hd__decap_3
XFILLER_21_30 VSS VSS VDD VDD sky130_fd_sc_hd__decap_3
XFILLER_21_74 VSS VSS VDD VDD sky130_fd_sc_hd__fill_2
XFILLER_21_85 VSS VSS VDD VDD sky130_fd_sc_hd__decap_3
XFILLER_47_222 VSS VSS VDD VDD sky130_fd_sc_hd__fill_2
XFILLER_15_163 VSS VSS VDD VDD sky130_fd_sc_hd__decap_3
XFILLER_30_122 VSS VSS VDD VDD sky130_fd_sc_hd__fill_2
XFILLER_30_144 VSS VSS VDD VDD sky130_fd_sc_hd__decap_3
XFILLER_30_188 VSS VSS VDD VDD sky130_fd_sc_hd__decap_3
XFILLER_7_21 VSS VSS VDD VDD sky130_fd_sc_hd__decap_3
XFILLER_7_54 VSS VSS VDD VDD sky130_fd_sc_hd__fill_2
XFILLER_7_87 VSS VSS VDD VDD sky130_fd_sc_hd__decap_3
X_0623_ _0287_ _0298_ _0309_ _0317_ VSS VSS VDD VDD _0318_ sky130_fd_sc_hd__or4_1
XFILLER_38_277 VSS VSS VDD VDD sky130_fd_sc_hd__decap_3
XFILLER_53_203 VSS VSS VDD VDD sky130_fd_sc_hd__decap_3
X_1106_ regs\[26\]\[4\] net165 _0271_ VSS VSS VDD VDD _0228_ sky130_fd_sc_hd__mux2_1
XFILLER_21_100 VSS VSS VDD VDD sky130_fd_sc_hd__decap_3
XFILLER_21_122 VSS VSS VDD VDD sky130_fd_sc_hd__decap_3
XFILLER_42_29 VSS VSS VDD VDD sky130_fd_sc_hd__decap_3
X_1037_ regs\[18\]\[7\] net154 _0572_ VSS VSS VDD VDD _0167_ sky130_fd_sc_hd__mux2_1
XFILLER_29_222 VSS VSS VDD VDD sky130_fd_sc_hd__fill_2
XFILLER_16_85 VSS VSS VDD VDD sky130_fd_sc_hd__fill_1
XPHY_EDGE_ROW_11_Right_11 VSS VSS VDD VDD sky130_fd_sc_hd__decap_3
XPHY_EDGE_ROW_20_Right_20 VSS VSS VDD VDD sky130_fd_sc_hd__decap_3
XFILLER_57_81 VSS VSS VDD VDD sky130_fd_sc_hd__decap_3
XFILLER_50_206 VSS VSS VDD VDD sky130_fd_sc_hd__decap_3
XFILLER_50_239 VSS VSS VDD VDD sky130_fd_sc_hd__fill_2
X_0606_ net123 _0300_ VSS VSS VDD VDD _0301_ sky130_fd_sc_hd__and2_1
XFILLER_37_18 VSS VSS VDD VDD sky130_fd_sc_hd__decap_3
XFILLER_34_291 VSS VSS VDD VDD sky130_fd_sc_hd__decap_3
XFILLER_41_228 VSS VSS VDD VDD sky130_fd_sc_hd__decap_3
XFILLER_53_39 VSS VSS VDD VDD sky130_fd_sc_hd__decap_3
XTAP_TAPCELL_ROW_4_151 VSS VDD sky130_fd_sc_hd__tapvpwrvgnd_1
XFILLER_17_225 VSS VSS VDD VDD sky130_fd_sc_hd__decap_3
XFILLER_17_247 VSS VSS VDD VDD sky130_fd_sc_hd__decap_3
XFILLER_32_206 VSS VSS VDD VDD sky130_fd_sc_hd__fill_1
XTAP_TAPCELL_ROW_27_286 VSS VDD sky130_fd_sc_hd__tapvpwrvgnd_1
XFILLER_4_173 VSS VSS VDD VDD sky130_fd_sc_hd__decap_3
XFILLER_4_44 VSS VSS VDD VDD sky130_fd_sc_hd__decap_3
X_1371_ net88 _0225_ net53 VSS VSS VDD VDD regs\[26\]\[1\] sky130_fd_sc_hd__dfrtp_1
XTAP_TAPCELL_ROW_10_186 VSS VDD sky130_fd_sc_hd__tapvpwrvgnd_1
XTAP_TAPCELL_ROW_18_231 VSS VDD sky130_fd_sc_hd__tapvpwrvgnd_1
XFILLER_16_291 VSS VSS VDD VDD sky130_fd_sc_hd__fill_2
XFILLER_31_261 VSS VSS VDD VDD sky130_fd_sc_hd__decap_3
XFILLER_14_217 VSS VSS VDD VDD sky130_fd_sc_hd__decap_3
XFILLER_54_342 VSS VSS VDD VDD sky130_fd_sc_hd__fill_2
XTAP_TAPCELL_ROW_1_132 VSS VDD sky130_fd_sc_hd__tapvpwrvgnd_1
XFILLER_13_42 VSS VSS VDD VDD sky130_fd_sc_hd__decap_3
XFILLER_13_97 VSS VSS VDD VDD sky130_fd_sc_hd__fill_1
XFILLER_22_294 VSS VSS VDD VDD sky130_fd_sc_hd__decap_3
Xfanout98 net99 VSS VSS VDD VDD net98 sky130_fd_sc_hd__clkbuf_2
Xfanout87 net90 VSS VSS VDD VDD net87 sky130_fd_sc_hd__clkbuf_2
Xfanout76 net81 VSS VSS VDD VDD net76 sky130_fd_sc_hd__buf_2
Xfanout65 net72 VSS VSS VDD VDD net65 sky130_fd_sc_hd__clkbuf_4
Xfanout54 net55 VSS VSS VDD VDD net54 sky130_fd_sc_hd__clkbuf_2
Xfanout43 net44 VSS VSS VDD VDD net43 sky130_fd_sc_hd__buf_2
Xfanout32 _0296_ VSS VSS VDD VDD net32 sky130_fd_sc_hd__buf_2
XTAP_TAPCELL_ROW_24_267 VSS VDD sky130_fd_sc_hd__tapvpwrvgnd_1
XFILLER_38_83 VSS VSS VDD VDD sky130_fd_sc_hd__fill_1
XFILLER_38_94 VSS VSS VDD VDD sky130_fd_sc_hd__decap_3
XFILLER_49_169 VSS VSS VDD VDD sky130_fd_sc_hd__decap_3
XFILLER_57_191 VSS VSS VDD VDD sky130_fd_sc_hd__decap_3
XFILLER_13_294 VSS VSS VDD VDD sky130_fd_sc_hd__fill_2
XFILLER_54_71 VSS VSS VDD VDD sky130_fd_sc_hd__decap_3
X_0940_ net46 regs\[8\]\[0\] _0562_ VSS VSS VDD VDD _0080_ sky130_fd_sc_hd__mux2_1
XTAP_TAPCELL_ROW_15_212 VSS VDD sky130_fd_sc_hd__tapvpwrvgnd_1
XFILLER_9_243 VSS VSS VDD VDD sky130_fd_sc_hd__decap_3
XFILLER_9_210 VSS VSS VDD VDD sky130_fd_sc_hd__decap_3
X_0871_ net170 regs\[0\]\[3\] _0554_ VSS VSS VDD VDD _0019_ sky130_fd_sc_hd__mux2_1
XFILLER_28_309 VSS VSS VDD VDD sky130_fd_sc_hd__decap_3
XFILLER_48_3 VSS VSS VDD VDD sky130_fd_sc_hd__decap_3
X_1285_ net105 _0139_ net70 VSS VSS VDD VDD regs\[15\]\[3\] sky130_fd_sc_hd__dfrtp_1
X_1354_ net82 _0208_ net47 VSS VSS VDD VDD regs\[24\]\[0\] sky130_fd_sc_hd__dfrtp_1
XFILLER_48_180 VSS VSS VDD VDD sky130_fd_sc_hd__decap_3
XFILLER_51_323 VSS VSS VDD VDD sky130_fd_sc_hd__fill_1
XFILLER_11_209 VSS VSS VDD VDD sky130_fd_sc_hd__fill_1
XFILLER_50_18 VSS VSS VDD VDD sky130_fd_sc_hd__decap_3
XFILLER_50_29 VSS VSS VDD VDD sky130_fd_sc_hd__decap_3
XTAP_TAPCELL_ROW_21_248 VSS VDD sky130_fd_sc_hd__tapvpwrvgnd_1
XFILLER_1_9 VSS VSS VDD VDD sky130_fd_sc_hd__decap_3
XFILLER_24_41 VSS VSS VDD VDD sky130_fd_sc_hd__decap_3
XFILLER_24_74 VSS VSS VDD VDD sky130_fd_sc_hd__decap_3
XFILLER_24_85 VSS VSS VDD VDD sky130_fd_sc_hd__decap_3
XFILLER_54_150 VSS VSS VDD VDD sky130_fd_sc_hd__fill_2
XFILLER_10_253 VSS VSS VDD VDD sky130_fd_sc_hd__decap_3
XFILLER_10_297 VSS VSS VDD VDD sky130_fd_sc_hd__decap_3
XFILLER_6_235 VSS VSS VDD VDD sky130_fd_sc_hd__decap_3
XFILLER_1_12 VSS VSS VDD VDD sky130_fd_sc_hd__decap_3
XFILLER_34_9 VSS VSS VDD VDD sky130_fd_sc_hd__decap_3
XFILLER_49_60 VSS VSS VDD VDD sky130_fd_sc_hd__decap_3
XFILLER_1_45 VSS VSS VDD VDD sky130_fd_sc_hd__decap_3
XFILLER_1_78 VSS VSS VDD VDD sky130_fd_sc_hd__decap_3
XFILLER_33_301 VSS VSS VDD VDD sky130_fd_sc_hd__decap_3
XFILLER_37_128 VSS VSS VDD VDD sky130_fd_sc_hd__decap_3
X_1070_ regs\[22\]\[4\] net166 _0267_ VSS VSS VDD VDD _0196_ sky130_fd_sc_hd__mux2_1
X_0923_ regs\[6\]\[1\] net41 _0560_ VSS VSS VDD VDD _0065_ sky130_fd_sc_hd__mux2_1
X_0854_ regs\[20\]\[7\] _0320_ _0326_ _0540_ _0541_ VSS VSS VDD VDD _0542_ sky130_fd_sc_hd__a2111o_1
XTAP_TAPCELL_ROW_43_384 VSS VDD sky130_fd_sc_hd__tapvpwrvgnd_1
X_0785_ net117 regs\[25\]\[5\] net29 VSS VSS VDD VDD _0475_ sky130_fd_sc_hd__and3_1
XPHY_EDGE_ROW_49_Right_49 VSS VSS VDD VDD sky130_fd_sc_hd__decap_3
XFILLER_28_106 VSS VSS VDD VDD sky130_fd_sc_hd__decap_3
XFILLER_28_139 VSS VSS VDD VDD sky130_fd_sc_hd__fill_1
XFILLER_45_18 VSS VSS VDD VDD sky130_fd_sc_hd__decap_3
X_1268_ net100 _0122_ net65 VSS VSS VDD VDD regs\[13\]\[2\] sky130_fd_sc_hd__dfrtp_1
X_1337_ net105 _0191_ net70 VSS VSS VDD VDD regs\[21\]\[7\] sky130_fd_sc_hd__dfrtp_1
X_1406_ net115 _0260_ net80 VSS VSS VDD VDD regs\[30\]\[4\] sky130_fd_sc_hd__dfrtp_1
XFILLER_24_312 VSS VSS VDD VDD sky130_fd_sc_hd__decap_3
XFILLER_36_161 VSS VSS VDD VDD sky130_fd_sc_hd__decap_3
X_1199_ net106 _0053_ net71 VSS VSS VDD VDD regs\[4\]\[5\] sky130_fd_sc_hd__dfrtp_1
XFILLER_10_21 VSS VSS VDD VDD sky130_fd_sc_hd__decap_3
XFILLER_10_32 VSS VSS VDD VDD sky130_fd_sc_hd__decap_3
XFILLER_19_30 VSS VSS VDD VDD sky130_fd_sc_hd__decap_3
XFILLER_19_85 VSS VSS VDD VDD sky130_fd_sc_hd__decap_3
XFILLER_27_150 VSS VSS VDD VDD sky130_fd_sc_hd__decap_3
XFILLER_34_109 VSS VSS VDD VDD sky130_fd_sc_hd__decap_3
XTAP_TAPCELL_ROW_57_465 VSS VDD sky130_fd_sc_hd__tapvpwrvgnd_1
XFILLER_42_153 VSS VSS VDD VDD sky130_fd_sc_hd__fill_2
XFILLER_51_72 VSS VSS VDD VDD sky130_fd_sc_hd__decap_3
XTAP_TAPCELL_ROW_40_365 VSS VDD sky130_fd_sc_hd__tapvpwrvgnd_1
XFILLER_32_6 VSS VSS VDD VDD sky130_fd_sc_hd__decap_3
X_1122_ regs\[28\]\[2\] net174 _0273_ VSS VSS VDD VDD _0242_ sky130_fd_sc_hd__mux2_1
XTAP_TAPCELL_ROW_48_410 VSS VDD sky130_fd_sc_hd__tapvpwrvgnd_1
XFILLER_18_161 VSS VSS VDD VDD sky130_fd_sc_hd__decap_3
XFILLER_18_194 VSS VSS VDD VDD sky130_fd_sc_hd__fill_2
XFILLER_21_337 VSS VSS VDD VDD sky130_fd_sc_hd__decap_3
XFILLER_33_131 VSS VSS VDD VDD sky130_fd_sc_hd__decap_3
XFILLER_33_164 VSS VSS VDD VDD sky130_fd_sc_hd__decap_3
XFILLER_33_175 VSS VSS VDD VDD sky130_fd_sc_hd__decap_3
X_1053_ regs\[20\]\[5\] net163 _0265_ VSS VSS VDD VDD _0181_ sky130_fd_sc_hd__mux2_1
XTAP_TAPCELL_ROW_31_310 VSS VDD sky130_fd_sc_hd__tapvpwrvgnd_1
X_0906_ net172 regs\[4\]\[2\] _0558_ VSS VSS VDD VDD _0050_ sky130_fd_sc_hd__mux2_1
X_0837_ net146 net23 _0524_ _0525_ VSS VSS VDD VDD _0014_ sky130_fd_sc_hd__a22o_1
XFILLER_0_219 VSS VSS VDD VDD sky130_fd_sc_hd__decap_3
X_0768_ regs\[7\]\[4\] _0304_ _0456_ _0457_ _0458_ VSS VSS VDD VDD _0459_ sky130_fd_sc_hd__a2111o_1
X_0699_ _0379_ _0383_ _0387_ _0391_ VSS VSS VDD VDD _0392_ sky130_fd_sc_hd__or4_1
XFILLER_24_153 VSS VSS VDD VDD sky130_fd_sc_hd__decap_3
XTAP_TAPCELL_ROW_54_446 VSS VDD sky130_fd_sc_hd__tapvpwrvgnd_1
XFILLER_21_42 VSS VSS VDD VDD sky130_fd_sc_hd__decap_3
XFILLER_21_97 VSS VSS VDD VDD sky130_fd_sc_hd__decap_3
XFILLER_30_101 VSS VSS VDD VDD sky130_fd_sc_hd__decap_3
XFILLER_46_50 VSS VSS VDD VDD sky130_fd_sc_hd__decap_3
XFILLER_46_83 VSS VSS VDD VDD sky130_fd_sc_hd__fill_1
XFILLER_47_278 VSS VSS VDD VDD sky130_fd_sc_hd__fill_2
XFILLER_30_156 VSS VSS VDD VDD sky130_fd_sc_hd__decap_3
XFILLER_7_33 VSS VSS VDD VDD sky130_fd_sc_hd__decap_3
XFILLER_7_330 VSS VSS VDD VDD sky130_fd_sc_hd__fill_2
XFILLER_7_66 VSS VSS VDD VDD sky130_fd_sc_hd__decap_3
XFILLER_30_3 VSS VSS VDD VDD sky130_fd_sc_hd__decap_3
XFILLER_7_99 VSS VSS VDD VDD sky130_fd_sc_hd__decap_3
X_0622_ regs\[9\]\[0\] _0316_ _0314_ _0311_ _0310_ VSS VSS VDD VDD _0317_ sky130_fd_sc_hd__a2111o_1
XFILLER_38_289 VSS VSS VDD VDD sky130_fd_sc_hd__decap_3
XFILLER_53_215 VSS VSS VDD VDD sky130_fd_sc_hd__fill_2
XFILLER_53_237 VSS VSS VDD VDD sky130_fd_sc_hd__fill_2
XFILLER_53_248 VSS VSS VDD VDD sky130_fd_sc_hd__decap_3
X_1105_ regs\[26\]\[3\] net170 _0271_ VSS VSS VDD VDD _0227_ sky130_fd_sc_hd__mux2_1
XFILLER_21_156 VSS VSS VDD VDD sky130_fd_sc_hd__decap_3
XFILLER_21_167 VSS VSS VDD VDD sky130_fd_sc_hd__fill_1
XFILLER_42_19 VSS VSS VDD VDD sky130_fd_sc_hd__decap_3
X_1036_ regs\[18\]\[6\] net159 _0572_ VSS VSS VDD VDD _0166_ sky130_fd_sc_hd__mux2_1
XFILLER_29_278 VSS VSS VDD VDD sky130_fd_sc_hd__fill_2
XFILLER_32_41 VSS VSS VDD VDD sky130_fd_sc_hd__decap_3
XFILLER_32_85 VSS VSS VDD VDD sky130_fd_sc_hd__decap_3
XFILLER_57_60 VSS VSS VDD VDD sky130_fd_sc_hd__decap_3
XFILLER_35_259 VSS VSS VDD VDD sky130_fd_sc_hd__decap_3
XFILLER_43_270 VSS VSS VDD VDD sky130_fd_sc_hd__fill_1
XFILLER_50_218 VSS VSS VDD VDD sky130_fd_sc_hd__decap_3
XPHY_EDGE_ROW_44_Left_102 VSS VSS VDD VDD sky130_fd_sc_hd__decap_3
X_0605_ net175 net141 net139 net143 VSS VSS VDD VDD _0300_ sky130_fd_sc_hd__and4bb_2
XFILLER_26_259 VSS VSS VDD VDD sky130_fd_sc_hd__fill_2
XFILLER_53_18 VSS VSS VDD VDD sky130_fd_sc_hd__decap_3
X_1019_ regs\[16\]\[7\] net154 _0570_ VSS VSS VDD VDD _0151_ sky130_fd_sc_hd__mux2_1
XPHY_EDGE_ROW_53_Left_111 VSS VSS VDD VDD sky130_fd_sc_hd__decap_3
XFILLER_27_30 VSS VSS VDD VDD sky130_fd_sc_hd__fill_1
XFILLER_49_318 VSS VSS VDD VDD sky130_fd_sc_hd__decap_3
XFILLER_57_340 VSS VSS VDD VDD sky130_fd_sc_hd__decap_3
XFILLER_17_259 VSS VSS VDD VDD sky130_fd_sc_hd__decap_3
XFILLER_25_281 VSS VSS VDD VDD sky130_fd_sc_hd__decap_3
XFILLER_43_51 VSS VSS VDD VDD sky130_fd_sc_hd__decap_3
XTAP_TAPCELL_ROW_27_287 VSS VDD sky130_fd_sc_hd__tapvpwrvgnd_1
XFILLER_4_141 VSS VSS VDD VDD sky130_fd_sc_hd__fill_1
XTAP_TAPCELL_ROW_10_187 VSS VDD sky130_fd_sc_hd__tapvpwrvgnd_1
XFILLER_4_12 VSS VSS VDD VDD sky130_fd_sc_hd__decap_3
XFILLER_4_185 VSS VSS VDD VDD sky130_fd_sc_hd__fill_2
XFILLER_4_56 VSS VSS VDD VDD sky130_fd_sc_hd__decap_3
X_1370_ net84 _0224_ net49 VSS VSS VDD VDD regs\[26\]\[0\] sky130_fd_sc_hd__dfrtp_1
XTAP_TAPCELL_ROW_18_232 VSS VDD sky130_fd_sc_hd__tapvpwrvgnd_1
XFILLER_31_284 VSS VSS VDD VDD sky130_fd_sc_hd__decap_3
XFILLER_39_340 VSS VSS VDD VDD sky130_fd_sc_hd__decap_3
XFILLER_48_18 VSS VSS VDD VDD sky130_fd_sc_hd__decap_3
XFILLER_48_29 VSS VSS VDD VDD sky130_fd_sc_hd__decap_3
XFILLER_54_321 VSS VSS VDD VDD sky130_fd_sc_hd__decap_3
XTAP_TAPCELL_ROW_1_133 VSS VDD sky130_fd_sc_hd__tapvpwrvgnd_1
XFILLER_14_229 VSS VSS VDD VDD sky130_fd_sc_hd__decap_3
XFILLER_22_240 VSS VSS VDD VDD sky130_fd_sc_hd__decap_3
Xfanout55 net7 VSS VSS VDD VDD net55 sky130_fd_sc_hd__clkbuf_2
Xfanout44 net45 VSS VSS VDD VDD net44 sky130_fd_sc_hd__buf_2
Xfanout33 _0293_ VSS VSS VDD VDD net33 sky130_fd_sc_hd__clkbuf_4
XTAP_TAPCELL_ROW_24_268 VSS VDD sky130_fd_sc_hd__tapvpwrvgnd_1
XFILLER_13_21 VSS VSS VDD VDD sky130_fd_sc_hd__decap_3
Xfanout99 net6 VSS VSS VDD VDD net99 sky130_fd_sc_hd__buf_2
Xfanout88 net90 VSS VSS VDD VDD net88 sky130_fd_sc_hd__clkbuf_2
Xfanout77 net81 VSS VSS VDD VDD net77 sky130_fd_sc_hd__clkbuf_4
Xfanout66 net72 VSS VSS VDD VDD net66 sky130_fd_sc_hd__buf_2
XFILLER_1_111 VSS VSS VDD VDD sky130_fd_sc_hd__fill_1
XFILLER_1_122 VSS VSS VDD VDD sky130_fd_sc_hd__decap_3
XFILLER_8_3 VSS VSS VDD VDD sky130_fd_sc_hd__decap_3
XFILLER_45_332 VSS VSS VDD VDD sky130_fd_sc_hd__decap_3
XFILLER_45_343 VSS VSS VDD VDD sky130_fd_sc_hd__fill_1
XFILLER_54_50 VSS VSS VDD VDD sky130_fd_sc_hd__decap_3
XFILLER_57_181 VSS VSS VDD VDD sky130_fd_sc_hd__fill_2
XFILLER_13_251 VSS VSS VDD VDD sky130_fd_sc_hd__decap_3
XFILLER_54_83 VSS VSS VDD VDD sky130_fd_sc_hd__fill_1
X_0870_ net173 regs\[0\]\[2\] _0554_ VSS VSS VDD VDD _0018_ sky130_fd_sc_hd__mux2_1
XTAP_TAPCELL_ROW_15_213 VSS VDD sky130_fd_sc_hd__tapvpwrvgnd_1
XFILLER_9_222 VSS VSS VDD VDD sky130_fd_sc_hd__fill_2
XFILLER_55_107 VSS VSS VDD VDD sky130_fd_sc_hd__decap_3
X_1284_ net96 _0138_ net61 VSS VSS VDD VDD regs\[15\]\[2\] sky130_fd_sc_hd__dfrtp_1
X_1353_ net102 _0207_ net67 VSS VSS VDD VDD regs\[23\]\[7\] sky130_fd_sc_hd__dfrtp_1
XFILLER_36_321 VSS VSS VDD VDD sky130_fd_sc_hd__decap_3
XFILLER_51_302 VSS VSS VDD VDD sky130_fd_sc_hd__fill_2
X_0999_ regs\[14\]\[5\] net162 _0568_ VSS VSS VDD VDD _0133_ sky130_fd_sc_hd__mux2_1
XTAP_TAPCELL_ROW_21_249 VSS VDD sky130_fd_sc_hd__tapvpwrvgnd_1
XFILLER_27_343 VSS VSS VDD VDD sky130_fd_sc_hd__fill_1
XFILLER_39_181 VSS VSS VDD VDD sky130_fd_sc_hd__decap_3
XFILLER_10_221 VSS VSS VDD VDD sky130_fd_sc_hd__decap_3
XFILLER_24_64 VSS VSS VDD VDD sky130_fd_sc_hd__decap_3
XFILLER_24_97 VSS VSS VDD VDD sky130_fd_sc_hd__decap_3
XFILLER_10_287 VSS VSS VDD VDD sky130_fd_sc_hd__fill_1
XFILLER_40_85 VSS VSS VDD VDD sky130_fd_sc_hd__decap_3
XFILLER_6_247 VSS VSS VDD VDD sky130_fd_sc_hd__decap_3
XFILLER_1_24 VSS VSS VDD VDD sky130_fd_sc_hd__decap_3
XFILLER_27_9 VSS VSS VDD VDD sky130_fd_sc_hd__decap_3
XFILLER_49_72 VSS VSS VDD VDD sky130_fd_sc_hd__decap_3
XFILLER_1_57 VSS VSS VDD VDD sky130_fd_sc_hd__decap_3
XFILLER_45_140 VSS VSS VDD VDD sky130_fd_sc_hd__decap_3
XFILLER_45_151 VSS VSS VDD VDD sky130_fd_sc_hd__decap_3
X_0922_ regs\[6\]\[0\] net45 _0560_ VSS VSS VDD VDD _0064_ sky130_fd_sc_hd__mux2_1
X_0853_ net129 regs\[30\]\[7\] net33 VSS VSS VDD VDD _0541_ sky130_fd_sc_hd__and3_1
XTAP_TAPCELL_ROW_43_385 VSS VDD sky130_fd_sc_hd__tapvpwrvgnd_1
X_1405_ net113 _0259_ net78 VSS VSS VDD VDD regs\[30\]\[3\] sky130_fd_sc_hd__dfrtp_1
X_0784_ net117 regs\[13\]\[5\] net30 VSS VSS VDD VDD _0474_ sky130_fd_sc_hd__and3b_1
X_1267_ net87 _0121_ net52 VSS VSS VDD VDD regs\[13\]\[1\] sky130_fd_sc_hd__dfrtp_1
X_1336_ net102 _0190_ net67 VSS VSS VDD VDD regs\[21\]\[6\] sky130_fd_sc_hd__dfrtp_1
Xinput1 addr[0] VSS VSS VDD VDD net1 sky130_fd_sc_hd__clkbuf_1
X_1198_ net114 _0052_ net79 VSS VSS VDD VDD regs\[4\]\[4\] sky130_fd_sc_hd__dfrtp_1
XFILLER_36_195 VSS VSS VDD VDD sky130_fd_sc_hd__fill_1
XTAP_TAPCELL_ROW_34_330 VSS VDD sky130_fd_sc_hd__tapvpwrvgnd_1
XFILLER_19_107 VSS VSS VDD VDD sky130_fd_sc_hd__decap_3
XFILLER_15_335 VSS VSS VDD VDD sky130_fd_sc_hd__fill_1
XFILLER_35_30 VSS VSS VDD VDD sky130_fd_sc_hd__decap_3
XFILLER_35_63 VSS VSS VDD VDD sky130_fd_sc_hd__decap_3
XTAP_TAPCELL_ROW_57_466 VSS VDD sky130_fd_sc_hd__tapvpwrvgnd_1
XFILLER_30_338 VSS VSS VDD VDD sky130_fd_sc_hd__decap_3
XFILLER_42_176 VSS VSS VDD VDD sky130_fd_sc_hd__decap_3
XFILLER_42_187 VSS VSS VDD VDD sky130_fd_sc_hd__decap_3
XFILLER_51_51 VSS VSS VDD VDD sky130_fd_sc_hd__decap_3
XFILLER_51_95 VSS VSS VDD VDD sky130_fd_sc_hd__decap_3
XTAP_TAPCELL_ROW_40_366 VSS VDD sky130_fd_sc_hd__tapvpwrvgnd_1
XFILLER_2_250 VSS VSS VDD VDD sky130_fd_sc_hd__fill_2
XFILLER_25_6 VSS VSS VDD VDD sky130_fd_sc_hd__decap_3
X_1121_ regs\[28\]\[1\] net42 _0273_ VSS VSS VDD VDD _0241_ sky130_fd_sc_hd__mux2_1
X_1052_ regs\[20\]\[4\] net166 _0265_ VSS VSS VDD VDD _0180_ sky130_fd_sc_hd__mux2_1
XTAP_TAPCELL_ROW_48_411 VSS VDD sky130_fd_sc_hd__tapvpwrvgnd_1
XFILLER_33_143 VSS VSS VDD VDD sky130_fd_sc_hd__decap_3
XFILLER_33_154 VSS VSS VDD VDD sky130_fd_sc_hd__fill_1
XTAP_TAPCELL_ROW_31_311 VSS VDD sky130_fd_sc_hd__tapvpwrvgnd_1
X_0905_ net40 regs\[4\]\[1\] _0558_ VSS VSS VDD VDD _0049_ sky130_fd_sc_hd__mux2_1
X_0836_ regs\[0\]\[6\] _0327_ net145 VSS VSS VDD VDD _0525_ sky130_fd_sc_hd__o21ba_1
X_0767_ net119 regs\[27\]\[4\] net31 VSS VSS VDD VDD _0458_ sky130_fd_sc_hd__and3_1
XFILLER_56_18 VSS VSS VDD VDD sky130_fd_sc_hd__decap_3
XFILLER_56_29 VSS VSS VDD VDD sky130_fd_sc_hd__decap_3
X_0698_ regs\[13\]\[2\] _0313_ _0388_ _0389_ _0390_ VSS VSS VDD VDD _0391_ sky130_fd_sc_hd__a2111o_1
X_1319_ net92 _0173_ net57 VSS VSS VDD VDD regs\[19\]\[5\] sky130_fd_sc_hd__dfrtp_1
XTAP_TAPCELL_ROW_54_447 VSS VDD sky130_fd_sc_hd__tapvpwrvgnd_1
XFILLER_21_21 VSS VSS VDD VDD sky130_fd_sc_hd__decap_3
XFILLER_24_165 VSS VSS VDD VDD sky130_fd_sc_hd__decap_3
XFILLER_8_309 VSS VSS VDD VDD sky130_fd_sc_hd__fill_2
XFILLER_21_54 VSS VSS VDD VDD sky130_fd_sc_hd__fill_2
XFILLER_21_65 VSS VSS VDD VDD sky130_fd_sc_hd__decap_3
XFILLER_30_113 VSS VSS VDD VDD sky130_fd_sc_hd__decap_3
XFILLER_30_168 VSS VSS VDD VDD sky130_fd_sc_hd__fill_1
XFILLER_7_12 VSS VSS VDD VDD sky130_fd_sc_hd__decap_3
XFILLER_7_45 VSS VSS VDD VDD sky130_fd_sc_hd__decap_3
XFILLER_7_78 VSS VSS VDD VDD sky130_fd_sc_hd__decap_3
X_0621_ net121 net29 VSS VSS VDD VDD _0316_ sky130_fd_sc_hd__and2b_2
XFILLER_23_3 VSS VSS VDD VDD sky130_fd_sc_hd__decap_3
XFILLER_38_246 VSS VSS VDD VDD sky130_fd_sc_hd__decap_3
XFILLER_38_268 VSS VSS VDD VDD sky130_fd_sc_hd__decap_3
XFILLER_46_290 VSS VSS VDD VDD sky130_fd_sc_hd__decap_3
X_1104_ regs\[26\]\[2\] net173 _0271_ VSS VSS VDD VDD _0226_ sky130_fd_sc_hd__mux2_1
X_1035_ regs\[18\]\[5\] net163 _0572_ VSS VSS VDD VDD _0165_ sky130_fd_sc_hd__mux2_1
XTAP_TAPCELL_ROW_51_428 VSS VDD sky130_fd_sc_hd__tapvpwrvgnd_1
X_0819_ net117 regs\[25\]\[6\] net29 VSS VSS VDD VDD _0508_ sky130_fd_sc_hd__and3_1
XFILLER_29_246 VSS VSS VDD VDD sky130_fd_sc_hd__decap_3
XFILLER_12_135 VSS VSS VDD VDD sky130_fd_sc_hd__fill_1
XFILLER_16_21 VSS VSS VDD VDD sky130_fd_sc_hd__decap_3
XFILLER_16_32 VSS VSS VDD VDD sky130_fd_sc_hd__decap_3
XFILLER_16_98 VSS VSS VDD VDD sky130_fd_sc_hd__decap_3
XFILLER_44_227 VSS VSS VDD VDD sky130_fd_sc_hd__decap_3
XFILLER_52_282 VSS VSS VDD VDD sky130_fd_sc_hd__fill_2
XFILLER_32_53 VSS VSS VDD VDD sky130_fd_sc_hd__fill_1
XFILLER_4_312 VSS VSS VDD VDD sky130_fd_sc_hd__decap_3
XFILLER_8_139 VSS VSS VDD VDD sky130_fd_sc_hd__fill_1
XFILLER_57_50 VSS VSS VDD VDD sky130_fd_sc_hd__decap_3
XFILLER_57_72 VSS VSS VDD VDD sky130_fd_sc_hd__decap_3
XFILLER_57_94 VSS VSS VDD VDD sky130_fd_sc_hd__decap_3
XFILLER_7_161 VSS VSS VDD VDD sky130_fd_sc_hd__decap_3
XFILLER_7_194 VSS VSS VDD VDD sky130_fd_sc_hd__decap_3
X_0604_ net122 net37 VSS VSS VDD VDD _0299_ sky130_fd_sc_hd__and2b_4
XPHY_EDGE_ROW_9_Right_9 VSS VSS VDD VDD sky130_fd_sc_hd__decap_3
XFILLER_26_238 VSS VSS VDD VDD sky130_fd_sc_hd__decap_3
XFILLER_34_282 VSS VSS VDD VDD sky130_fd_sc_hd__decap_3
X_1018_ regs\[16\]\[6\] net157 _0570_ VSS VSS VDD VDD _0150_ sky130_fd_sc_hd__mux2_1
XFILLER_1_337 VSS VSS VDD VDD sky130_fd_sc_hd__decap_3
XFILLER_17_238 VSS VSS VDD VDD sky130_fd_sc_hd__decap_3
XFILLER_57_330 VSS VSS VDD VDD sky130_fd_sc_hd__decap_3
XFILLER_32_219 VSS VSS VDD VDD sky130_fd_sc_hd__fill_2
XFILLER_43_30 VSS VSS VDD VDD sky130_fd_sc_hd__decap_3
XTAP_TAPCELL_ROW_27_288 VSS VDD sky130_fd_sc_hd__tapvpwrvgnd_1
XFILLER_4_24 VSS VSS VDD VDD sky130_fd_sc_hd__decap_3
XFILLER_57_9 VSS VSS VDD VDD sky130_fd_sc_hd__decap_3
XFILLER_48_330 VSS VSS VDD VDD sky130_fd_sc_hd__decap_3
XFILLER_48_341 VSS VSS VDD VDD sky130_fd_sc_hd__decap_3
XFILLER_4_197 VSS VSS VDD VDD sky130_fd_sc_hd__decap_3
XFILLER_4_35 VSS VSS VDD VDD sky130_fd_sc_hd__decap_3
XFILLER_16_282 VSS VSS VDD VDD sky130_fd_sc_hd__decap_3
XTAP_TAPCELL_ROW_18_233 VSS VDD sky130_fd_sc_hd__tapvpwrvgnd_1
XFILLER_31_252 VSS VSS VDD VDD sky130_fd_sc_hd__decap_3
XPHY_EDGE_ROW_18_Left_76 VSS VSS VDD VDD sky130_fd_sc_hd__decap_3
XFILLER_54_333 VSS VSS VDD VDD sky130_fd_sc_hd__decap_3
XFILLER_13_33 VSS VSS VDD VDD sky130_fd_sc_hd__decap_3
Xfanout89 net90 VSS VSS VDD VDD net89 sky130_fd_sc_hd__buf_1
Xfanout78 net81 VSS VSS VDD VDD net78 sky130_fd_sc_hd__clkbuf_2
Xfanout67 net72 VSS VSS VDD VDD net67 sky130_fd_sc_hd__clkbuf_4
Xfanout56 net64 VSS VSS VDD VDD net56 sky130_fd_sc_hd__clkbuf_4
Xfanout45 net46 VSS VSS VDD VDD net45 sky130_fd_sc_hd__clkbuf_2
Xfanout34 _0290_ VSS VSS VDD VDD net34 sky130_fd_sc_hd__clkbuf_4
XTAP_TAPCELL_ROW_24_269 VSS VDD sky130_fd_sc_hd__tapvpwrvgnd_1
XFILLER_13_55 VSS VSS VDD VDD sky130_fd_sc_hd__fill_1
XFILLER_13_88 VSS VSS VDD VDD sky130_fd_sc_hd__decap_3
XFILLER_38_41 VSS VSS VDD VDD sky130_fd_sc_hd__decap_3
XFILLER_38_74 VSS VSS VDD VDD sky130_fd_sc_hd__decap_3
XFILLER_38_85 VSS VSS VDD VDD sky130_fd_sc_hd__decap_3
XFILLER_54_62 VSS VSS VDD VDD sky130_fd_sc_hd__decap_3
XTAP_TAPCELL_ROW_15_214 VSS VDD sky130_fd_sc_hd__tapvpwrvgnd_1
XFILLER_13_274 VSS VSS VDD VDD sky130_fd_sc_hd__decap_3
XFILLER_55_6 VSS VSS VDD VDD sky130_fd_sc_hd__decap_3
XFILLER_48_171 VSS VSS VDD VDD sky130_fd_sc_hd__fill_2
XFILLER_55_119 VSS VSS VDD VDD sky130_fd_sc_hd__fill_1
X_1283_ net108 _0137_ net73 VSS VSS VDD VDD regs\[15\]\[1\] sky130_fd_sc_hd__dfrtp_1
X_1352_ net104 _0206_ net69 VSS VSS VDD VDD regs\[23\]\[6\] sky130_fd_sc_hd__dfrtp_1
XFILLER_51_314 VSS VSS VDD VDD sky130_fd_sc_hd__decap_3
X_0998_ regs\[14\]\[4\] net167 _0568_ VSS VSS VDD VDD _0132_ sky130_fd_sc_hd__mux2_1
XFILLER_39_193 VSS VSS VDD VDD sky130_fd_sc_hd__fill_1
XFILLER_10_200 VSS VSS VDD VDD sky130_fd_sc_hd__decap_3
XFILLER_24_21 VSS VSS VDD VDD sky130_fd_sc_hd__decap_3
XFILLER_24_32 VSS VSS VDD VDD sky130_fd_sc_hd__decap_3
XFILLER_1_36 VSS VSS VDD VDD sky130_fd_sc_hd__decap_3
XFILLER_1_69 VSS VSS VDD VDD sky130_fd_sc_hd__decap_3
XFILLER_49_51 VSS VSS VDD VDD sky130_fd_sc_hd__decap_3
XFILLER_33_314 VSS VSS VDD VDD sky130_fd_sc_hd__fill_2
X_0921_ net146 _0297_ VSS VSS VDD VDD _0560_ sky130_fd_sc_hd__and2_4
XFILLER_53_3 VSS VSS VDD VDD sky130_fd_sc_hd__decap_3
X_0852_ net129 regs\[21\]\[7\] net34 VSS VSS VDD VDD _0540_ sky130_fd_sc_hd__and3_1
X_0783_ net118 regs\[9\]\[5\] net29 VSS VSS VDD VDD _0473_ sky130_fd_sc_hd__and3b_1
X_1335_ net113 _0189_ net78 VSS VSS VDD VDD regs\[21\]\[5\] sky130_fd_sc_hd__dfrtp_1
X_1404_ net95 _0258_ net60 VSS VSS VDD VDD regs\[30\]\[2\] sky130_fd_sc_hd__dfrtp_1
X_1266_ net100 _0120_ net65 VSS VSS VDD VDD regs\[13\]\[0\] sky130_fd_sc_hd__dfrtp_1
Xinput2 addr[1] VSS VSS VDD VDD net2 sky130_fd_sc_hd__clkbuf_1
X_1197_ net106 _0051_ net71 VSS VSS VDD VDD regs\[4\]\[3\] sky130_fd_sc_hd__dfrtp_1
XFILLER_51_144 VSS VSS VDD VDD sky130_fd_sc_hd__decap_3
XFILLER_51_199 VSS VSS VDD VDD sky130_fd_sc_hd__decap_3
XTAP_TAPCELL_ROW_34_331 VSS VDD sky130_fd_sc_hd__tapvpwrvgnd_1
XFILLER_10_12 VSS VSS VDD VDD sky130_fd_sc_hd__decap_3
XFILLER_3_218 VSS VSS VDD VDD sky130_fd_sc_hd__decap_3
XFILLER_19_21 VSS VSS VDD VDD sky130_fd_sc_hd__decap_3
XFILLER_19_76 VSS VSS VDD VDD sky130_fd_sc_hd__decap_3
XFILLER_19_98 VSS VSS VDD VDD sky130_fd_sc_hd__decap_3
XFILLER_27_141 VSS VSS VDD VDD sky130_fd_sc_hd__decap_3
XFILLER_27_196 VSS VSS VDD VDD sky130_fd_sc_hd__fill_2
XFILLER_35_42 VSS VSS VDD VDD sky130_fd_sc_hd__decap_3
XFILLER_35_75 VSS VSS VDD VDD sky130_fd_sc_hd__decap_3
XFILLER_42_144 VSS VSS VDD VDD sky130_fd_sc_hd__decap_3
XTAP_TAPCELL_ROW_57_467 VSS VDD sky130_fd_sc_hd__tapvpwrvgnd_1
XFILLER_51_30 VSS VSS VDD VDD sky130_fd_sc_hd__decap_3
XFILLER_51_63 VSS VSS VDD VDD sky130_fd_sc_hd__decap_3
XTAP_TAPCELL_ROW_40_367 VSS VDD sky130_fd_sc_hd__tapvpwrvgnd_1
XFILLER_2_273 VSS VSS VDD VDD sky130_fd_sc_hd__decap_3
XFILLER_18_141 VSS VSS VDD VDD sky130_fd_sc_hd__fill_2
XFILLER_18_152 VSS VSS VDD VDD sky130_fd_sc_hd__decap_3
XFILLER_18_6 VSS VSS VDD VDD sky130_fd_sc_hd__decap_3
XFILLER_33_111 VSS VSS VDD VDD sky130_fd_sc_hd__fill_1
X_1120_ regs\[28\]\[0\] net44 _0273_ VSS VSS VDD VDD _0240_ sky130_fd_sc_hd__mux2_1
X_1051_ regs\[20\]\[3\] net169 _0265_ VSS VSS VDD VDD _0179_ sky130_fd_sc_hd__mux2_1
XTAP_TAPCELL_ROW_48_412 VSS VDD sky130_fd_sc_hd__tapvpwrvgnd_1
XFILLER_21_306 VSS VSS VDD VDD sky130_fd_sc_hd__decap_3
XFILLER_33_122 VSS VSS VDD VDD sky130_fd_sc_hd__decap_3
X_0904_ net44 regs\[4\]\[0\] _0558_ VSS VSS VDD VDD _0048_ sky130_fd_sc_hd__mux2_1
XTAP_TAPCELL_ROW_31_312 VSS VDD sky130_fd_sc_hd__tapvpwrvgnd_1
X_0835_ _0510_ _0516_ _0523_ VSS VSS VDD VDD _0524_ sky130_fd_sc_hd__or3_1
X_0766_ net119 regs\[25\]\[4\] net29 VSS VSS VDD VDD _0457_ sky130_fd_sc_hd__and3_1
X_0697_ net127 regs\[25\]\[2\] _0315_ VSS VSS VDD VDD _0390_ sky130_fd_sc_hd__and3_1
X_1318_ net94 _0172_ net59 VSS VSS VDD VDD regs\[19\]\[4\] sky130_fd_sc_hd__dfrtp_1
XFILLER_12_306 VSS VSS VDD VDD sky130_fd_sc_hd__fill_2
XFILLER_24_100 VSS VSS VDD VDD sky130_fd_sc_hd__decap_3
XFILLER_24_133 VSS VSS VDD VDD sky130_fd_sc_hd__decap_3
XFILLER_24_144 VSS VSS VDD VDD sky130_fd_sc_hd__decap_3
X_1249_ net110 _0103_ net75 VSS VSS VDD VDD regs\[10\]\[7\] sky130_fd_sc_hd__dfrtp_1
XTAP_TAPCELL_ROW_54_448 VSS VDD sky130_fd_sc_hd__tapvpwrvgnd_1
XFILLER_12_339 VSS VSS VDD VDD sky130_fd_sc_hd__fill_1
XFILLER_21_33 VSS VSS VDD VDD sky130_fd_sc_hd__decap_3
XFILLER_21_88 VSS VSS VDD VDD sky130_fd_sc_hd__decap_3
XFILLER_46_41 VSS VSS VDD VDD sky130_fd_sc_hd__decap_3
XFILLER_46_85 VSS VSS VDD VDD sky130_fd_sc_hd__decap_3
XPHY_EDGE_ROW_6_Left_64 VSS VSS VDD VDD sky130_fd_sc_hd__decap_3
XFILLER_15_166 VSS VSS VDD VDD sky130_fd_sc_hd__fill_2
XFILLER_30_147 VSS VSS VDD VDD sky130_fd_sc_hd__decap_3
XFILLER_7_24 VSS VSS VDD VDD sky130_fd_sc_hd__decap_3
X_0620_ net143 net141 net139 net175 VSS VSS VDD VDD _0315_ sky130_fd_sc_hd__and4bb_1
XFILLER_16_3 VSS VSS VDD VDD sky130_fd_sc_hd__decap_3
XFILLER_21_103 VSS VSS VDD VDD sky130_fd_sc_hd__decap_3
XFILLER_53_206 VSS VSS VDD VDD sky130_fd_sc_hd__decap_3
X_1103_ regs\[26\]\[1\] net39 _0271_ VSS VSS VDD VDD _0225_ sky130_fd_sc_hd__mux2_1
X_1034_ regs\[18\]\[4\] net166 _0572_ VSS VSS VDD VDD _0164_ sky130_fd_sc_hd__mux2_1
XFILLER_21_125 VSS VSS VDD VDD sky130_fd_sc_hd__fill_2
XFILLER_21_147 VSS VSS VDD VDD sky130_fd_sc_hd__decap_3
XFILLER_21_169 VSS VSS VDD VDD sky130_fd_sc_hd__decap_3
XTAP_TAPCELL_ROW_51_429 VSS VDD sky130_fd_sc_hd__tapvpwrvgnd_1
X_0818_ net119 regs\[26\]\[6\] _0300_ VSS VSS VDD VDD _0507_ sky130_fd_sc_hd__and3_1
X_0749_ net131 regs\[12\]\[4\] _0285_ VSS VSS VDD VDD _0440_ sky130_fd_sc_hd__and3b_1
XFILLER_29_225 VSS VSS VDD VDD sky130_fd_sc_hd__decap_3
XFILLER_44_206 VSS VSS VDD VDD sky130_fd_sc_hd__fill_1
XFILLER_32_21 VSS VSS VDD VDD sky130_fd_sc_hd__decap_3
XFILLER_8_118 VSS VSS VDD VDD sky130_fd_sc_hd__decap_3
XFILLER_20_191 VSS VSS VDD VDD sky130_fd_sc_hd__decap_3
XFILLER_32_32 VSS VSS VDD VDD sky130_fd_sc_hd__decap_3
XFILLER_50_209 VSS VSS VDD VDD sky130_fd_sc_hd__decap_3
X_0603_ regs\[6\]\[0\] _0297_ _0295_ _0292_ _0289_ VSS VSS VDD VDD _0298_ sky130_fd_sc_hd__a2111o_1
XFILLER_34_294 VSS VSS VDD VDD sky130_fd_sc_hd__decap_3
X_1017_ regs\[16\]\[5\] net162 _0570_ VSS VSS VDD VDD _0149_ sky130_fd_sc_hd__mux2_1
XFILLER_17_228 VSS VSS VDD VDD sky130_fd_sc_hd__fill_1
XFILLER_27_21 VSS VSS VDD VDD sky130_fd_sc_hd__decap_3
XFILLER_25_294 VSS VSS VDD VDD sky130_fd_sc_hd__decap_3
XFILLER_40_231 VSS VSS VDD VDD sky130_fd_sc_hd__decap_3
XFILLER_43_42 VSS VSS VDD VDD sky130_fd_sc_hd__decap_3
XTAP_TAPCELL_ROW_27_289 VSS VDD sky130_fd_sc_hd__tapvpwrvgnd_1
XFILLER_4_165 VSS VSS VDD VDD sky130_fd_sc_hd__fill_1
XFILLER_4_176 VSS VSS VDD VDD sky130_fd_sc_hd__decap_3
XFILLER_4_47 VSS VSS VDD VDD sky130_fd_sc_hd__decap_3
XFILLER_31_220 VSS VSS VDD VDD sky130_fd_sc_hd__decap_3
XTAP_TAPCELL_ROW_18_234 VSS VDD sky130_fd_sc_hd__tapvpwrvgnd_1
XFILLER_31_264 VSS VSS VDD VDD sky130_fd_sc_hd__fill_2
XFILLER_31_275 VSS VSS VDD VDD sky130_fd_sc_hd__decap_3
XFILLER_39_320 VSS VSS VDD VDD sky130_fd_sc_hd__decap_3
XFILLER_13_12 VSS VSS VDD VDD sky130_fd_sc_hd__decap_3
XFILLER_13_45 VSS VSS VDD VDD sky130_fd_sc_hd__fill_1
XFILLER_22_231 VSS VSS VDD VDD sky130_fd_sc_hd__decap_3
XFILLER_22_253 VSS VSS VDD VDD sky130_fd_sc_hd__decap_3
XFILLER_22_297 VSS VSS VDD VDD sky130_fd_sc_hd__decap_3
Xfanout79 net81 VSS VSS VDD VDD net79 sky130_fd_sc_hd__clkbuf_4
Xfanout68 net72 VSS VSS VDD VDD net68 sky130_fd_sc_hd__clkbuf_2
Xfanout57 net64 VSS VSS VDD VDD net57 sky130_fd_sc_hd__buf_2
Xfanout46 net8 VSS VSS VDD VDD net46 sky130_fd_sc_hd__buf_2
XFILLER_1_102 VSS VSS VDD VDD sky130_fd_sc_hd__decap_3
XFILLER_1_113 VSS VSS VDD VDD sky130_fd_sc_hd__decap_3
XFILLER_38_97 VSS VSS VDD VDD sky130_fd_sc_hd__decap_3
XFILLER_45_312 VSS VSS VDD VDD sky130_fd_sc_hd__fill_2
XFILLER_57_150 VSS VSS VDD VDD sky130_fd_sc_hd__fill_1
XFILLER_45_323 VSS VSS VDD VDD sky130_fd_sc_hd__decap_3
XFILLER_54_41 VSS VSS VDD VDD sky130_fd_sc_hd__decap_3
XFILLER_54_74 VSS VSS VDD VDD sky130_fd_sc_hd__decap_3
XFILLER_54_85 VSS VSS VDD VDD sky130_fd_sc_hd__decap_3
XFILLER_57_194 VSS VSS VDD VDD sky130_fd_sc_hd__fill_2
XTAP_TAPCELL_ROW_15_215 VSS VDD sky130_fd_sc_hd__tapvpwrvgnd_1
XPHY_EDGE_ROW_35_Left_93 VSS VSS VDD VDD sky130_fd_sc_hd__decap_3
XFILLER_9_246 VSS VSS VDD VDD sky130_fd_sc_hd__decap_3
XFILLER_9_213 VSS VSS VDD VDD sky130_fd_sc_hd__decap_3
XFILLER_48_6 VSS VSS VDD VDD sky130_fd_sc_hd__decap_3
X_1351_ net105 _0205_ net70 VSS VSS VDD VDD regs\[23\]\[5\] sky130_fd_sc_hd__dfrtp_1
XFILLER_48_150 VSS VSS VDD VDD sky130_fd_sc_hd__fill_1
XFILLER_48_183 VSS VSS VDD VDD sky130_fd_sc_hd__decap_3
X_1282_ net102 _0136_ net67 VSS VSS VDD VDD regs\[15\]\[0\] sky130_fd_sc_hd__dfrtp_1
X_0997_ regs\[14\]\[3\] net170 _0568_ VSS VSS VDD VDD _0131_ sky130_fd_sc_hd__mux2_1
XFILLER_27_301 VSS VSS VDD VDD sky130_fd_sc_hd__decap_3
XFILLER_27_334 VSS VSS VDD VDD sky130_fd_sc_hd__fill_2
XFILLER_39_172 VSS VSS VDD VDD sky130_fd_sc_hd__decap_3
XFILLER_42_315 VSS VSS VDD VDD sky130_fd_sc_hd__decap_3
XFILLER_54_197 VSS VSS VDD VDD sky130_fd_sc_hd__decap_3
XFILLER_10_212 VSS VSS VDD VDD sky130_fd_sc_hd__decap_3
XFILLER_10_256 VSS VSS VDD VDD sky130_fd_sc_hd__fill_2
XFILLER_10_278 VSS VSS VDD VDD sky130_fd_sc_hd__decap_3
XFILLER_24_44 VSS VSS VDD VDD sky130_fd_sc_hd__decap_3
XFILLER_24_77 VSS VSS VDD VDD sky130_fd_sc_hd__decap_3
XFILLER_24_88 VSS VSS VDD VDD sky130_fd_sc_hd__decap_3
XFILLER_40_21 VSS VSS VDD VDD sky130_fd_sc_hd__decap_3
XFILLER_40_32 VSS VSS VDD VDD sky130_fd_sc_hd__decap_3
XFILLER_6_238 VSS VSS VDD VDD sky130_fd_sc_hd__decap_3
XFILLER_49_30 VSS VSS VDD VDD sky130_fd_sc_hd__decap_3
XFILLER_49_63 VSS VSS VDD VDD sky130_fd_sc_hd__decap_3
XFILLER_18_301 VSS VSS VDD VDD sky130_fd_sc_hd__decap_3
XFILLER_1_15 VSS VSS VDD VDD sky130_fd_sc_hd__decap_3
XFILLER_1_48 VSS VSS VDD VDD sky130_fd_sc_hd__decap_3
XFILLER_45_131 VSS VSS VDD VDD sky130_fd_sc_hd__decap_3
XFILLER_33_304 VSS VSS VDD VDD sky130_fd_sc_hd__decap_3
X_0920_ regs\[5\]\[7\] net153 _0559_ VSS VSS VDD VDD _0063_ sky130_fd_sc_hd__mux2_1
XFILLER_5_271 VSS VSS VDD VDD sky130_fd_sc_hd__decap_3
X_0851_ regs\[2\]\[7\] _0336_ _0536_ _0537_ _0538_ VSS VSS VDD VDD _0539_ sky130_fd_sc_hd__a2111o_1
X_0782_ regs\[11\]\[5\] _0307_ _0338_ regs\[10\]\[5\] VSS VSS VDD VDD _0472_ sky130_fd_sc_hd__a22o_1
XFILLER_28_109 VSS VSS VDD VDD sky130_fd_sc_hd__fill_1
XFILLER_46_3 VSS VSS VDD VDD sky130_fd_sc_hd__decap_3
X_1265_ net87 _0119_ net52 VSS VSS VDD VDD regs\[12\]\[7\] sky130_fd_sc_hd__dfrtp_1
X_1334_ net108 _0188_ net73 VSS VSS VDD VDD regs\[21\]\[4\] sky130_fd_sc_hd__dfrtp_1
X_1403_ net104 _0257_ net69 VSS VSS VDD VDD regs\[30\]\[1\] sky130_fd_sc_hd__dfrtp_1
XPHY_EDGE_ROW_18_Right_18 VSS VSS VDD VDD sky130_fd_sc_hd__decap_3
XFILLER_24_315 VSS VSS VDD VDD sky130_fd_sc_hd__fill_1
XFILLER_36_164 VSS VSS VDD VDD sky130_fd_sc_hd__decap_3
XFILLER_36_186 VSS VSS VDD VDD sky130_fd_sc_hd__decap_3
XFILLER_36_197 VSS VSS VDD VDD sky130_fd_sc_hd__decap_3
Xinput3 addr[2] VSS VSS VDD VDD net3 sky130_fd_sc_hd__clkbuf_1
X_1196_ net112 _0050_ net77 VSS VSS VDD VDD regs\[4\]\[2\] sky130_fd_sc_hd__dfrtp_1
XPHY_EDGE_ROW_27_Right_27 VSS VSS VDD VDD sky130_fd_sc_hd__decap_3
XFILLER_10_24 VSS VSS VDD VDD sky130_fd_sc_hd__decap_3
XFILLER_10_35 VSS VSS VDD VDD sky130_fd_sc_hd__decap_3
XPHY_EDGE_ROW_36_Right_36 VSS VSS VDD VDD sky130_fd_sc_hd__decap_3
XFILLER_19_33 VSS VSS VDD VDD sky130_fd_sc_hd__decap_3
XFILLER_19_88 VSS VSS VDD VDD sky130_fd_sc_hd__fill_1
XFILLER_27_153 VSS VSS VDD VDD sky130_fd_sc_hd__decap_3
XTAP_TAPCELL_ROW_57_468 VSS VDD sky130_fd_sc_hd__tapvpwrvgnd_1
XFILLER_30_329 VSS VSS VDD VDD sky130_fd_sc_hd__decap_3
XFILLER_35_21 VSS VSS VDD VDD sky130_fd_sc_hd__decap_3
XFILLER_42_167 VSS VSS VDD VDD sky130_fd_sc_hd__decap_3
XPHY_EDGE_ROW_45_Right_45 VSS VSS VDD VDD sky130_fd_sc_hd__decap_3
XFILLER_51_42 VSS VSS VDD VDD sky130_fd_sc_hd__decap_3
XFILLER_51_75 VSS VSS VDD VDD sky130_fd_sc_hd__decap_3
XPHY_EDGE_ROW_54_Right_54 VSS VSS VDD VDD sky130_fd_sc_hd__decap_3
XFILLER_32_9 VSS VSS VDD VDD sky130_fd_sc_hd__decap_3
XFILLER_18_120 VSS VSS VDD VDD sky130_fd_sc_hd__fill_2
XFILLER_18_131 VSS VSS VDD VDD sky130_fd_sc_hd__decap_3
XFILLER_33_134 VSS VSS VDD VDD sky130_fd_sc_hd__decap_3
X_1050_ regs\[20\]\[2\] net172 _0265_ VSS VSS VDD VDD _0178_ sky130_fd_sc_hd__mux2_1
XTAP_TAPCELL_ROW_48_413 VSS VDD sky130_fd_sc_hd__tapvpwrvgnd_1
XFILLER_33_167 VSS VSS VDD VDD sky130_fd_sc_hd__fill_1
XFILLER_33_178 VSS VSS VDD VDD sky130_fd_sc_hd__decap_3
X_0903_ net150 _0332_ VSS VSS VDD VDD _0558_ sky130_fd_sc_hd__nand2_4
X_0834_ _0517_ _0518_ _0522_ VSS VSS VDD VDD _0523_ sky130_fd_sc_hd__or3_1
XTAP_TAPCELL_ROW_31_313 VSS VDD sky130_fd_sc_hd__tapvpwrvgnd_1
X_0765_ net119 regs\[29\]\[4\] net30 VSS VSS VDD VDD _0456_ sky130_fd_sc_hd__and3_1
X_0696_ net125 regs\[24\]\[2\] _0340_ VSS VSS VDD VDD _0389_ sky130_fd_sc_hd__and3_1
XFILLER_2_80 VSS VSS VDD VDD sky130_fd_sc_hd__decap_3
XFILLER_2_91 VSS VSS VDD VDD sky130_fd_sc_hd__decap_3
X_1248_ net94 _0102_ net59 VSS VSS VDD VDD regs\[10\]\[6\] sky130_fd_sc_hd__dfrtp_1
X_1317_ net112 _0171_ net77 VSS VSS VDD VDD regs\[19\]\[3\] sky130_fd_sc_hd__dfrtp_1
XPHY_EDGE_ROW_22_Left_80 VSS VSS VDD VDD sky130_fd_sc_hd__decap_3
XFILLER_24_156 VSS VSS VDD VDD sky130_fd_sc_hd__decap_3
X_1179_ net91 _0033_ net56 VSS VSS VDD VDD regs\[2\]\[1\] sky130_fd_sc_hd__dfrtp_1
XTAP_TAPCELL_ROW_54_449 VSS VDD sky130_fd_sc_hd__tapvpwrvgnd_1
XFILLER_21_12 VSS VSS VDD VDD sky130_fd_sc_hd__decap_3
XFILLER_21_45 VSS VSS VDD VDD sky130_fd_sc_hd__decap_3
XFILLER_46_53 VSS VSS VDD VDD sky130_fd_sc_hd__decap_3
XFILLER_15_189 VSS VSS VDD VDD sky130_fd_sc_hd__decap_3
XFILLER_30_104 VSS VSS VDD VDD sky130_fd_sc_hd__decap_3
XFILLER_30_159 VSS VSS VDD VDD sky130_fd_sc_hd__decap_3
XFILLER_7_311 VSS VSS VDD VDD sky130_fd_sc_hd__decap_3
XFILLER_7_36 VSS VSS VDD VDD sky130_fd_sc_hd__decap_3
XFILLER_7_69 VSS VSS VDD VDD sky130_fd_sc_hd__decap_3
XFILLER_30_6 VSS VSS VDD VDD sky130_fd_sc_hd__decap_3
XFILLER_38_226 VSS VSS VDD VDD sky130_fd_sc_hd__fill_2
XFILLER_38_237 VSS VSS VDD VDD sky130_fd_sc_hd__decap_3
X_1102_ regs\[26\]\[0\] net46 _0271_ VSS VSS VDD VDD _0224_ sky130_fd_sc_hd__mux2_1
X_1033_ regs\[18\]\[3\] net171 _0572_ VSS VSS VDD VDD _0163_ sky130_fd_sc_hd__mux2_1
XFILLER_21_159 VSS VSS VDD VDD sky130_fd_sc_hd__decap_3
X_0817_ net117 regs\[13\]\[6\] net30 VSS VSS VDD VDD _0506_ sky130_fd_sc_hd__and3b_1
X_0748_ net124 regs\[11\]\[4\] net31 VSS VSS VDD VDD _0439_ sky130_fd_sc_hd__and3b_1
X_0679_ _0361_ _0364_ _0368_ _0372_ VSS VSS VDD VDD _0373_ sky130_fd_sc_hd__or4_1
XFILLER_16_12 VSS VSS VDD VDD sky130_fd_sc_hd__decap_3
XFILLER_37_281 VSS VSS VDD VDD sky130_fd_sc_hd__decap_3
XFILLER_16_67 VSS VSS VDD VDD sky130_fd_sc_hd__decap_3
XFILLER_52_251 VSS VSS VDD VDD sky130_fd_sc_hd__fill_1
XFILLER_52_262 VSS VSS VDD VDD sky130_fd_sc_hd__decap_3
XPHY_EDGE_ROW_0_Right_0 VSS VSS VDD VDD sky130_fd_sc_hd__decap_3
XFILLER_32_88 VSS VSS VDD VDD sky130_fd_sc_hd__fill_1
XFILLER_57_41 VSS VSS VDD VDD sky130_fd_sc_hd__decap_3
XFILLER_57_63 VSS VSS VDD VDD sky130_fd_sc_hd__decap_3
XFILLER_57_85 VSS VSS VDD VDD sky130_fd_sc_hd__decap_3
XFILLER_43_240 VSS VSS VDD VDD sky130_fd_sc_hd__decap_3
XFILLER_11_181 VSS VSS VDD VDD sky130_fd_sc_hd__decap_3
X_0602_ net131 net32 VSS VSS VDD VDD _0297_ sky130_fd_sc_hd__and2b_2
XFILLER_19_292 VSS VSS VDD VDD sky130_fd_sc_hd__decap_3
XFILLER_34_251 VSS VSS VDD VDD sky130_fd_sc_hd__fill_1
X_1016_ regs\[16\]\[4\] net165 _0570_ VSS VSS VDD VDD _0148_ sky130_fd_sc_hd__mux2_1
XFILLER_57_321 VSS VSS VDD VDD sky130_fd_sc_hd__decap_3
XFILLER_57_343 VSS VSS VDD VDD sky130_fd_sc_hd__fill_1
XFILLER_25_284 VSS VSS VDD VDD sky130_fd_sc_hd__fill_1
XFILLER_27_66 VSS VSS VDD VDD sky130_fd_sc_hd__decap_3
XFILLER_43_21 VSS VSS VDD VDD sky130_fd_sc_hd__decap_3
XFILLER_43_54 VSS VSS VDD VDD sky130_fd_sc_hd__fill_2
XFILLER_4_15 VSS VSS VDD VDD sky130_fd_sc_hd__decap_3
XFILLER_4_59 VSS VSS VDD VDD sky130_fd_sc_hd__decap_3
XFILLER_48_321 VSS VSS VDD VDD sky130_fd_sc_hd__decap_3
XFILLER_16_251 VSS VSS VDD VDD sky130_fd_sc_hd__fill_1
XTAP_TAPCELL_ROW_18_235 VSS VDD sky130_fd_sc_hd__tapvpwrvgnd_1
XFILLER_31_287 VSS VSS VDD VDD sky130_fd_sc_hd__decap_3
XFILLER_39_332 VSS VSS VDD VDD sky130_fd_sc_hd__decap_3
XFILLER_39_343 VSS VSS VDD VDD sky130_fd_sc_hd__fill_1
XFILLER_54_324 VSS VSS VDD VDD sky130_fd_sc_hd__decap_3
XFILLER_13_24 VSS VSS VDD VDD sky130_fd_sc_hd__decap_3
XFILLER_13_57 VSS VSS VDD VDD sky130_fd_sc_hd__decap_3
XFILLER_22_243 VSS VSS VDD VDD sky130_fd_sc_hd__decap_3
Xfanout69 net72 VSS VSS VDD VDD net69 sky130_fd_sc_hd__clkbuf_4
Xfanout58 net59 VSS VSS VDD VDD net58 sky130_fd_sc_hd__clkbuf_4
Xfanout47 net50 VSS VSS VDD VDD net47 sky130_fd_sc_hd__clkbuf_4
Xfanout36 _0285_ VSS VSS VDD VDD net36 sky130_fd_sc_hd__buf_2
XFILLER_1_125 VSS VSS VDD VDD sky130_fd_sc_hd__decap_3
XFILLER_8_6 VSS VSS VDD VDD sky130_fd_sc_hd__decap_3
XFILLER_1_169 VSS VSS VDD VDD sky130_fd_sc_hd__fill_2
XFILLER_38_21 VSS VSS VDD VDD sky130_fd_sc_hd__decap_3
XFILLER_38_32 VSS VSS VDD VDD sky130_fd_sc_hd__decap_3
XFILLER_45_335 VSS VSS VDD VDD sky130_fd_sc_hd__fill_1
XFILLER_13_221 VSS VSS VDD VDD sky130_fd_sc_hd__decap_3
XFILLER_13_265 VSS VSS VDD VDD sky130_fd_sc_hd__decap_3
XFILLER_54_53 VSS VSS VDD VDD sky130_fd_sc_hd__decap_3
XTAP_TAPCELL_ROW_15_216 VSS VDD sky130_fd_sc_hd__tapvpwrvgnd_1
XTAP_TAPCELL_ROW_23_260 VSS VDD sky130_fd_sc_hd__tapvpwrvgnd_1
X_1281_ net86 _0135_ net51 VSS VSS VDD VDD regs\[14\]\[7\] sky130_fd_sc_hd__dfrtp_1
X_1350_ net103 _0204_ net68 VSS VSS VDD VDD regs\[23\]\[4\] sky130_fd_sc_hd__dfrtp_1
X_0996_ regs\[14\]\[2\] net173 _0568_ VSS VSS VDD VDD _0130_ sky130_fd_sc_hd__mux2_1
XFILLER_39_162 VSS VSS VDD VDD sky130_fd_sc_hd__decap_3
XFILLER_39_184 VSS VSS VDD VDD sky130_fd_sc_hd__decap_3
XFILLER_24_12 VSS VSS VDD VDD sky130_fd_sc_hd__decap_3
XFILLER_24_67 VSS VSS VDD VDD sky130_fd_sc_hd__fill_1
XFILLER_10_224 VSS VSS VDD VDD sky130_fd_sc_hd__decap_3
XFILLER_49_42 VSS VSS VDD VDD sky130_fd_sc_hd__decap_3
XFILLER_6_3 VSS VSS VDD VDD sky130_fd_sc_hd__decap_3
XFILLER_1_27 VSS VSS VDD VDD sky130_fd_sc_hd__decap_3
XFILLER_45_110 VSS VSS VDD VDD sky130_fd_sc_hd__fill_2
XFILLER_45_143 VSS VSS VDD VDD sky130_fd_sc_hd__fill_2
XFILLER_45_154 VSS VSS VDD VDD sky130_fd_sc_hd__decap_3
X_0850_ net125 regs\[5\]\[7\] net34 VSS VSS VDD VDD _0538_ sky130_fd_sc_hd__and3b_1
XFILLER_5_261 VSS VSS VDD VDD sky130_fd_sc_hd__fill_1
X_1402_ net102 _0256_ net67 VSS VSS VDD VDD regs\[30\]\[0\] sky130_fd_sc_hd__dfrtp_1
X_0781_ regs\[19\]\[5\] _0324_ _0336_ regs\[2\]\[5\] VSS VSS VDD VDD _0471_ sky130_fd_sc_hd__a22o_1
XFILLER_39_3 VSS VSS VDD VDD sky130_fd_sc_hd__decap_3
X_1264_ net115 _0118_ net80 VSS VSS VDD VDD regs\[12\]\[6\] sky130_fd_sc_hd__dfrtp_1
X_1333_ net113 _0187_ net78 VSS VSS VDD VDD regs\[21\]\[3\] sky130_fd_sc_hd__dfrtp_1
Xinput4 addr[3] VSS VSS VDD VDD net4 sky130_fd_sc_hd__clkbuf_1
XFILLER_51_113 VSS VSS VDD VDD sky130_fd_sc_hd__fill_2
XFILLER_51_124 VSS VSS VDD VDD sky130_fd_sc_hd__decap_3
X_1195_ net114 _0049_ net79 VSS VSS VDD VDD regs\[4\]\[1\] sky130_fd_sc_hd__dfrtp_1
X_0979_ regs\[12\]\[3\] net168 _0566_ VSS VSS VDD VDD _0115_ sky130_fd_sc_hd__mux2_1
XFILLER_19_12 VSS VSS VDD VDD sky130_fd_sc_hd__decap_3
XFILLER_27_132 VSS VSS VDD VDD sky130_fd_sc_hd__decap_3
XFILLER_35_33 VSS VSS VDD VDD sky130_fd_sc_hd__decap_3
XTAP_TAPCELL_ROW_57_469 VSS VDD sky130_fd_sc_hd__tapvpwrvgnd_1
XFILLER_35_55 VSS VSS VDD VDD sky130_fd_sc_hd__fill_1
XFILLER_35_66 VSS VSS VDD VDD sky130_fd_sc_hd__decap_3
XFILLER_42_179 VSS VSS VDD VDD sky130_fd_sc_hd__fill_1
XFILLER_51_21 VSS VSS VDD VDD sky130_fd_sc_hd__decap_3
XFILLER_51_54 VSS VSS VDD VDD sky130_fd_sc_hd__fill_2
XFILLER_51_98 VSS VSS VDD VDD sky130_fd_sc_hd__fill_1
XFILLER_25_9 VSS VSS VDD VDD sky130_fd_sc_hd__decap_3
XTAP_TAPCELL_ROW_48_414 VSS VDD sky130_fd_sc_hd__tapvpwrvgnd_1
XFILLER_33_102 VSS VSS VDD VDD sky130_fd_sc_hd__decap_3
XFILLER_33_146 VSS VSS VDD VDD sky130_fd_sc_hd__fill_1
X_0902_ regs\[3\]\[7\] net151 _0557_ VSS VSS VDD VDD _0047_ sky130_fd_sc_hd__mux2_1
X_0833_ regs\[4\]\[6\] _0332_ _0519_ _0520_ _0521_ VSS VSS VDD VDD _0522_ sky130_fd_sc_hd__a2111o_1
X_0764_ _0451_ _0452_ _0453_ _0454_ VSS VSS VDD VDD _0455_ sky130_fd_sc_hd__or4_1
X_0695_ net125 regs\[21\]\[2\] net34 VSS VSS VDD VDD _0388_ sky130_fd_sc_hd__and3_1
XFILLER_56_249 VSS VSS VDD VDD sky130_fd_sc_hd__decap_3
X_1247_ net91 _0101_ net56 VSS VSS VDD VDD regs\[10\]\[5\] sky130_fd_sc_hd__dfrtp_1
X_1316_ net112 _0170_ net77 VSS VSS VDD VDD regs\[19\]\[2\] sky130_fd_sc_hd__dfrtp_1
X_1178_ net87 _0032_ net52 VSS VSS VDD VDD regs\[2\]\[0\] sky130_fd_sc_hd__dfrtp_1
XFILLER_20_330 VSS VSS VDD VDD sky130_fd_sc_hd__decap_3
XFILLER_24_168 VSS VSS VDD VDD sky130_fd_sc_hd__decap_3
XFILLER_21_24 VSS VSS VDD VDD sky130_fd_sc_hd__decap_3
XFILLER_21_68 VSS VSS VDD VDD sky130_fd_sc_hd__decap_3
XFILLER_47_216 VSS VSS VDD VDD sky130_fd_sc_hd__decap_3
XFILLER_46_21 VSS VSS VDD VDD sky130_fd_sc_hd__decap_3
XFILLER_46_32 VSS VSS VDD VDD sky130_fd_sc_hd__decap_3
XFILLER_23_190 VSS VSS VDD VDD sky130_fd_sc_hd__decap_3
XFILLER_30_116 VSS VSS VDD VDD sky130_fd_sc_hd__decap_3
XFILLER_30_138 VSS VSS VDD VDD sky130_fd_sc_hd__fill_2
XFILLER_7_15 VSS VSS VDD VDD sky130_fd_sc_hd__decap_3
XFILLER_7_48 VSS VSS VDD VDD sky130_fd_sc_hd__decap_3
XFILLER_23_6 VSS VSS VDD VDD sky130_fd_sc_hd__decap_3
XFILLER_38_249 VSS VSS VDD VDD sky130_fd_sc_hd__decap_3
X_1101_ net119 net148 _0300_ VSS VSS VDD VDD _0271_ sky130_fd_sc_hd__and3_4
X_1032_ regs\[18\]\[2\] net10 _0572_ VSS VSS VDD VDD _0162_ sky130_fd_sc_hd__mux2_1
XFILLER_14_190 VSS VSS VDD VDD sky130_fd_sc_hd__decap_3
XFILLER_46_293 VSS VSS VDD VDD sky130_fd_sc_hd__decap_3
X_0816_ regs\[3\]\[6\] _0284_ _0333_ regs\[23\]\[6\] _0504_ VSS VSS VDD VDD _0505_
+ sky130_fd_sc_hd__a221o_1
X_0747_ regs\[4\]\[4\] _0332_ _0435_ _0436_ _0437_ VSS VSS VDD VDD _0438_ sky130_fd_sc_hd__a2111o_1
X_0678_ regs\[4\]\[1\] _0332_ _0369_ _0370_ _0371_ VSS VSS VDD VDD _0372_ sky130_fd_sc_hd__a2111o_1
XFILLER_16_24 VSS VSS VDD VDD sky130_fd_sc_hd__decap_3
XFILLER_16_35 VSS VSS VDD VDD sky130_fd_sc_hd__decap_3
XFILLER_29_249 VSS VSS VDD VDD sky130_fd_sc_hd__decap_3
XFILLER_32_12 VSS VSS VDD VDD sky130_fd_sc_hd__decap_3
XFILLER_4_315 VSS VSS VDD VDD sky130_fd_sc_hd__fill_2
XFILLER_57_53 VSS VSS VDD VDD sky130_fd_sc_hd__decap_3
XFILLER_57_75 VSS VSS VDD VDD sky130_fd_sc_hd__decap_3
XFILLER_57_97 VSS VSS VDD VDD sky130_fd_sc_hd__decap_3
XTAP_TAPCELL_ROW_7_164 VSS VDD sky130_fd_sc_hd__tapvpwrvgnd_1
XFILLER_28_293 VSS VSS VDD VDD sky130_fd_sc_hd__decap_3
XFILLER_43_252 VSS VSS VDD VDD sky130_fd_sc_hd__decap_3
XFILLER_43_285 VSS VSS VDD VDD sky130_fd_sc_hd__decap_3
XFILLER_7_164 VSS VSS VDD VDD sky130_fd_sc_hd__decap_3
XFILLER_7_197 VSS VSS VDD VDD sky130_fd_sc_hd__fill_2
X_0601_ net176 net140 net142 net144 VSS VSS VDD VDD _0296_ sky130_fd_sc_hd__and4bb_1
XFILLER_21_3 VSS VSS VDD VDD sky130_fd_sc_hd__decap_3
X_1015_ regs\[16\]\[3\] net170 _0570_ VSS VSS VDD VDD _0147_ sky130_fd_sc_hd__mux2_1
XFILLER_34_285 VSS VSS VDD VDD sky130_fd_sc_hd__decap_3
XFILLER_27_12 VSS VSS VDD VDD sky130_fd_sc_hd__decap_3
XFILLER_57_333 VSS VSS VDD VDD sky130_fd_sc_hd__decap_3
XFILLER_40_222 VSS VSS VDD VDD sky130_fd_sc_hd__decap_3
XFILLER_43_33 VSS VSS VDD VDD sky130_fd_sc_hd__decap_3
XFILLER_0_340 VSS VSS VDD VDD sky130_fd_sc_hd__decap_3
XFILLER_4_27 VSS VSS VDD VDD sky130_fd_sc_hd__fill_1
XFILLER_4_38 VSS VSS VDD VDD sky130_fd_sc_hd__decap_3
XFILLER_16_230 VSS VSS VDD VDD sky130_fd_sc_hd__decap_3
XFILLER_48_333 VSS VSS VDD VDD sky130_fd_sc_hd__fill_2
XFILLER_16_285 VSS VSS VDD VDD sky130_fd_sc_hd__decap_3
XFILLER_31_211 VSS VSS VDD VDD sky130_fd_sc_hd__decap_3
XFILLER_31_255 VSS VSS VDD VDD sky130_fd_sc_hd__decap_3
XFILLER_31_299 VSS VSS VDD VDD sky130_fd_sc_hd__decap_3
XTAP_TAPCELL_ROW_26_280 VSS VDD sky130_fd_sc_hd__tapvpwrvgnd_1
XFILLER_22_200 VSS VSS VDD VDD sky130_fd_sc_hd__decap_3
XFILLER_22_222 VSS VSS VDD VDD sky130_fd_sc_hd__decap_3
XFILLER_54_336 VSS VSS VDD VDD sky130_fd_sc_hd__decap_3
Xfanout26 net27 VSS VSS VDD VDD net26 sky130_fd_sc_hd__clkbuf_4
XFILLER_13_36 VSS VSS VDD VDD sky130_fd_sc_hd__decap_3
XFILLER_22_288 VSS VSS VDD VDD sky130_fd_sc_hd__decap_3
Xfanout59 net64 VSS VSS VDD VDD net59 sky130_fd_sc_hd__clkbuf_4
Xfanout48 net50 VSS VSS VDD VDD net48 sky130_fd_sc_hd__clkbuf_4
XFILLER_38_77 VSS VSS VDD VDD sky130_fd_sc_hd__decap_3
XFILLER_38_88 VSS VSS VDD VDD sky130_fd_sc_hd__decap_3
XFILLER_54_10 VSS VSS VDD VDD sky130_fd_sc_hd__decap_3
XFILLER_54_32 VSS VSS VDD VDD sky130_fd_sc_hd__decap_3
XFILLER_57_141 VSS VSS VDD VDD sky130_fd_sc_hd__decap_3
XFILLER_57_163 VSS VSS VDD VDD sky130_fd_sc_hd__fill_1
XFILLER_57_174 VSS VSS VDD VDD sky130_fd_sc_hd__decap_3
XFILLER_13_277 VSS VSS VDD VDD sky130_fd_sc_hd__decap_3
XFILLER_54_65 VSS VSS VDD VDD sky130_fd_sc_hd__decap_3
XTAP_TAPCELL_ROW_23_261 VSS VDD sky130_fd_sc_hd__tapvpwrvgnd_1
XTAP_TAPCELL_ROW_15_217 VSS VDD sky130_fd_sc_hd__tapvpwrvgnd_1
XFILLER_55_9 VSS VSS VDD VDD sky130_fd_sc_hd__decap_3
XFILLER_0_192 VSS VSS VDD VDD sky130_fd_sc_hd__decap_3
X_1280_ net111 _0134_ net76 VSS VSS VDD VDD regs\[14\]\[6\] sky130_fd_sc_hd__dfrtp_1
XPHY_EDGE_ROW_50_Left_108 VSS VSS VDD VDD sky130_fd_sc_hd__decap_3
XFILLER_51_317 VSS VSS VDD VDD sky130_fd_sc_hd__decap_3
X_0995_ regs\[14\]\[1\] net40 _0568_ VSS VSS VDD VDD _0129_ sky130_fd_sc_hd__mux2_1
XFILLER_10_203 VSS VSS VDD VDD sky130_fd_sc_hd__decap_3
XFILLER_24_24 VSS VSS VDD VDD sky130_fd_sc_hd__decap_3
XFILLER_24_35 VSS VSS VDD VDD sky130_fd_sc_hd__decap_3
XFILLER_42_306 VSS VSS VDD VDD sky130_fd_sc_hd__fill_2
XFILLER_40_12 VSS VSS VDD VDD sky130_fd_sc_hd__decap_3
XFILLER_6_229 VSS VSS VDD VDD sky130_fd_sc_hd__decap_3
XTAP_TAPCELL_ROW_20_242 VSS VDD sky130_fd_sc_hd__tapvpwrvgnd_1
XFILLER_49_21 VSS VSS VDD VDD sky130_fd_sc_hd__decap_3
XFILLER_49_54 VSS VSS VDD VDD sky130_fd_sc_hd__fill_2
XFILLER_18_336 VSS VSS VDD VDD sky130_fd_sc_hd__fill_1
XFILLER_1_39 VSS VSS VDD VDD sky130_fd_sc_hd__decap_3
X_0780_ _0465_ _0466_ _0467_ _0469_ VSS VSS VDD VDD _0470_ sky130_fd_sc_hd__or4_1
XFILLER_53_6 VSS VSS VDD VDD sky130_fd_sc_hd__decap_3
X_1401_ net86 _0255_ net51 VSS VSS VDD VDD regs\[29\]\[7\] sky130_fd_sc_hd__dfrtp_1
X_1263_ net106 _0117_ net71 VSS VSS VDD VDD regs\[12\]\[5\] sky130_fd_sc_hd__dfrtp_1
X_1332_ net101 _0186_ net66 VSS VSS VDD VDD regs\[21\]\[2\] sky130_fd_sc_hd__dfrtp_1
Xinput5 addr[4] VSS VSS VDD VDD net5 sky130_fd_sc_hd__clkbuf_1
X_1194_ net104 _0048_ net69 VSS VSS VDD VDD regs\[4\]\[0\] sky130_fd_sc_hd__dfrtp_1
XFILLER_51_103 VSS VSS VDD VDD sky130_fd_sc_hd__decap_3
XFILLER_51_147 VSS VSS VDD VDD sky130_fd_sc_hd__decap_3
XFILLER_10_15 VSS VSS VDD VDD sky130_fd_sc_hd__decap_3
X_0978_ regs\[12\]\[2\] net172 _0566_ VSS VSS VDD VDD _0114_ sky130_fd_sc_hd__mux2_1
XFILLER_19_24 VSS VSS VDD VDD sky130_fd_sc_hd__decap_3
XFILLER_19_79 VSS VSS VDD VDD sky130_fd_sc_hd__decap_3
XFILLER_27_144 VSS VSS VDD VDD sky130_fd_sc_hd__decap_3
XFILLER_27_166 VSS VSS VDD VDD sky130_fd_sc_hd__fill_2
XFILLER_35_12 VSS VSS VDD VDD sky130_fd_sc_hd__decap_3
XFILLER_35_45 VSS VSS VDD VDD sky130_fd_sc_hd__fill_1
XFILLER_35_78 VSS VSS VDD VDD sky130_fd_sc_hd__decap_3
XFILLER_42_147 VSS VSS VDD VDD sky130_fd_sc_hd__decap_3
XFILLER_51_33 VSS VSS VDD VDD sky130_fd_sc_hd__decap_3
XFILLER_51_66 VSS VSS VDD VDD sky130_fd_sc_hd__decap_3
XFILLER_18_9 VSS VSS VDD VDD sky130_fd_sc_hd__decap_3
XTAP_TAPCELL_ROW_48_415 VSS VDD sky130_fd_sc_hd__tapvpwrvgnd_1
XFILLER_18_155 VSS VSS VDD VDD sky130_fd_sc_hd__decap_3
XFILLER_18_188 VSS VSS VDD VDD sky130_fd_sc_hd__decap_3
XFILLER_21_309 VSS VSS VDD VDD sky130_fd_sc_hd__decap_3
XFILLER_33_125 VSS VSS VDD VDD sky130_fd_sc_hd__decap_3
XFILLER_33_169 VSS VSS VDD VDD sky130_fd_sc_hd__decap_3
XFILLER_41_191 VSS VSS VDD VDD sky130_fd_sc_hd__fill_1
X_0901_ regs\[3\]\[6\] net158 _0557_ VSS VSS VDD VDD _0046_ sky130_fd_sc_hd__mux2_1
X_0832_ net135 regs\[12\]\[6\] _0285_ VSS VSS VDD VDD _0521_ sky130_fd_sc_hd__and3b_1
X_0763_ regs\[26\]\[4\] _0301_ _0324_ regs\[19\]\[4\] VSS VSS VDD VDD _0454_ sky130_fd_sc_hd__a22o_1
XFILLER_51_3 VSS VSS VDD VDD sky130_fd_sc_hd__decap_3
X_1315_ net109 _0169_ net74 VSS VSS VDD VDD regs\[19\]\[1\] sky130_fd_sc_hd__dfrtp_1
X_0694_ regs\[10\]\[2\] _0338_ _0384_ _0385_ _0386_ VSS VSS VDD VDD _0387_ sky130_fd_sc_hd__a2111o_1
XFILLER_24_103 VSS VSS VDD VDD sky130_fd_sc_hd__fill_1
XFILLER_2_71 VSS VSS VDD VDD sky130_fd_sc_hd__decap_3
X_1246_ net93 _0100_ net58 VSS VSS VDD VDD regs\[10\]\[4\] sky130_fd_sc_hd__dfrtp_1
X_1177_ net88 _0031_ net53 VSS VSS VDD VDD regs\[1\]\[7\] sky130_fd_sc_hd__dfrtp_1
XFILLER_24_136 VSS VSS VDD VDD sky130_fd_sc_hd__decap_3
XFILLER_24_147 VSS VSS VDD VDD sky130_fd_sc_hd__decap_3
XFILLER_21_36 VSS VSS VDD VDD sky130_fd_sc_hd__decap_3
XFILLER_47_206 VSS VSS VDD VDD sky130_fd_sc_hd__fill_1
XFILLER_46_44 VSS VSS VDD VDD sky130_fd_sc_hd__decap_3
XFILLER_46_88 VSS VSS VDD VDD sky130_fd_sc_hd__decap_3
XTAP_TAPCELL_ROW_53_440 VSS VDD sky130_fd_sc_hd__tapvpwrvgnd_1
XFILLER_7_27 VSS VSS VDD VDD sky130_fd_sc_hd__decap_3
XFILLER_7_302 VSS VSS VDD VDD sky130_fd_sc_hd__decap_3
XFILLER_16_6 VSS VSS VDD VDD sky130_fd_sc_hd__decap_3
XFILLER_53_209 VSS VSS VDD VDD sky130_fd_sc_hd__decap_3
X_1100_ regs\[25\]\[7\] net151 _0270_ VSS VSS VDD VDD _0223_ sky130_fd_sc_hd__mux2_1
X_1031_ regs\[18\]\[1\] net41 _0572_ VSS VSS VDD VDD _0161_ sky130_fd_sc_hd__mux2_1
X_0815_ net128 regs\[31\]\[6\] net38 VSS VSS VDD VDD _0504_ sky130_fd_sc_hd__and3_1
X_0746_ net136 regs\[22\]\[4\] net32 VSS VSS VDD VDD _0437_ sky130_fd_sc_hd__and3_1
XFILLER_29_228 VSS VSS VDD VDD sky130_fd_sc_hd__decap_3
X_0677_ net135 regs\[16\]\[1\] net26 VSS VSS VDD VDD _0371_ sky130_fd_sc_hd__and3_1
XFILLER_52_253 VSS VSS VDD VDD sky130_fd_sc_hd__decap_3
X_1229_ net95 _0083_ net60 VSS VSS VDD VDD regs\[8\]\[3\] sky130_fd_sc_hd__dfrtp_1
XFILLER_20_194 VSS VSS VDD VDD sky130_fd_sc_hd__fill_2
XFILLER_32_24 VSS VSS VDD VDD sky130_fd_sc_hd__decap_3
XFILLER_32_35 VSS VSS VDD VDD sky130_fd_sc_hd__decap_3
XTAP_TAPCELL_ROW_7_165 VSS VDD sky130_fd_sc_hd__tapvpwrvgnd_1
XFILLER_57_21 VSS VSS VDD VDD sky130_fd_sc_hd__decap_3
XFILLER_57_32 VSS VSS VDD VDD sky130_fd_sc_hd__decap_3
XFILLER_11_172 VSS VSS VDD VDD sky130_fd_sc_hd__decap_3
XFILLER_7_132 VSS VSS VDD VDD sky130_fd_sc_hd__decap_3
X_0600_ net131 regs\[14\]\[0\] _0293_ VSS VSS VDD VDD _0295_ sky130_fd_sc_hd__and3b_1
XFILLER_14_3 VSS VSS VDD VDD sky130_fd_sc_hd__decap_3
XFILLER_26_209 VSS VSS VDD VDD sky130_fd_sc_hd__decap_3
XFILLER_34_231 VSS VSS VDD VDD sky130_fd_sc_hd__decap_3
X_1014_ regs\[16\]\[2\] net173 _0570_ VSS VSS VDD VDD _0146_ sky130_fd_sc_hd__mux2_1
XFILLER_34_297 VSS VSS VDD VDD sky130_fd_sc_hd__decap_3
X_0729_ net129 regs\[31\]\[3\] net38 VSS VSS VDD VDD _0421_ sky130_fd_sc_hd__and3_1
XFILLER_27_24 VSS VSS VDD VDD sky130_fd_sc_hd__decap_3
XFILLER_57_312 VSS VSS VDD VDD sky130_fd_sc_hd__decap_3
XTAP_TAPCELL_ROW_4_146 VSS VDD sky130_fd_sc_hd__tapvpwrvgnd_1
XFILLER_25_297 VSS VSS VDD VDD sky130_fd_sc_hd__fill_1
XFILLER_40_234 VSS VSS VDD VDD sky130_fd_sc_hd__decap_3
XFILLER_43_12 VSS VSS VDD VDD sky130_fd_sc_hd__decap_3
XFILLER_43_45 VSS VSS VDD VDD sky130_fd_sc_hd__decap_3
XFILLER_0_330 VSS VSS VDD VDD sky130_fd_sc_hd__decap_3
XFILLER_4_179 VSS VSS VDD VDD sky130_fd_sc_hd__decap_3
XFILLER_31_223 VSS VSS VDD VDD sky130_fd_sc_hd__fill_1
XFILLER_31_278 VSS VSS VDD VDD sky130_fd_sc_hd__fill_2
XTAP_TAPCELL_ROW_26_281 VSS VDD sky130_fd_sc_hd__tapvpwrvgnd_1
XFILLER_39_323 VSS VSS VDD VDD sky130_fd_sc_hd__decap_3
XFILLER_13_15 VSS VSS VDD VDD sky130_fd_sc_hd__decap_3
XFILLER_22_212 VSS VSS VDD VDD sky130_fd_sc_hd__fill_1
XFILLER_22_234 VSS VSS VDD VDD sky130_fd_sc_hd__decap_3
XFILLER_22_256 VSS VSS VDD VDD sky130_fd_sc_hd__decap_3
Xfanout49 net50 VSS VSS VDD VDD net49 sky130_fd_sc_hd__clkbuf_2
Xfanout38 _0276_ VSS VSS VDD VDD net38 sky130_fd_sc_hd__buf_2
XFILLER_1_105 VSS VSS VDD VDD sky130_fd_sc_hd__decap_3
XFILLER_1_116 VSS VSS VDD VDD sky130_fd_sc_hd__decap_3
XFILLER_38_12 VSS VSS VDD VDD sky130_fd_sc_hd__decap_3
XFILLER_45_326 VSS VSS VDD VDD sky130_fd_sc_hd__decap_3
XFILLER_45_337 VSS VSS VDD VDD sky130_fd_sc_hd__decap_3
XFILLER_54_22 VSS VSS VDD VDD sky130_fd_sc_hd__decap_3
XFILLER_54_44 VSS VSS VDD VDD sky130_fd_sc_hd__decap_3
XFILLER_57_131 VSS VSS VDD VDD sky130_fd_sc_hd__decap_3
XFILLER_13_212 VSS VSS VDD VDD sky130_fd_sc_hd__decap_3
XFILLER_13_245 VSS VSS VDD VDD sky130_fd_sc_hd__decap_3
XFILLER_54_77 VSS VSS VDD VDD sky130_fd_sc_hd__decap_3
XTAP_TAPCELL_ROW_23_262 VSS VDD sky130_fd_sc_hd__tapvpwrvgnd_1
XFILLER_9_249 VSS VSS VDD VDD sky130_fd_sc_hd__decap_3
XFILLER_9_216 VSS VSS VDD VDD sky130_fd_sc_hd__decap_3
XFILLER_48_9 VSS VSS VDD VDD sky130_fd_sc_hd__decap_3
XFILLER_48_197 VSS VSS VDD VDD sky130_fd_sc_hd__decap_3
XTAP_TAPCELL_ROW_46_398 VSS VDD sky130_fd_sc_hd__tapvpwrvgnd_1
X_0994_ regs\[14\]\[0\] net45 _0568_ VSS VSS VDD VDD _0128_ sky130_fd_sc_hd__mux2_1
XFILLER_27_304 VSS VSS VDD VDD sky130_fd_sc_hd__decap_3
XFILLER_27_337 VSS VSS VDD VDD sky130_fd_sc_hd__decap_3
XFILLER_39_175 VSS VSS VDD VDD sky130_fd_sc_hd__decap_3
XFILLER_42_318 VSS VSS VDD VDD sky130_fd_sc_hd__decap_3
XFILLER_54_112 VSS VSS VDD VDD sky130_fd_sc_hd__decap_3
XFILLER_10_215 VSS VSS VDD VDD sky130_fd_sc_hd__decap_3
XFILLER_10_248 VSS VSS VDD VDD sky130_fd_sc_hd__decap_3
XFILLER_24_47 VSS VSS VDD VDD sky130_fd_sc_hd__decap_3
XFILLER_40_24 VSS VSS VDD VDD sky130_fd_sc_hd__decap_3
XFILLER_40_35 VSS VSS VDD VDD sky130_fd_sc_hd__decap_3
XTAP_TAPCELL_ROW_20_243 VSS VDD sky130_fd_sc_hd__tapvpwrvgnd_1
XFILLER_18_304 VSS VSS VDD VDD sky130_fd_sc_hd__decap_3
XFILLER_1_18 VSS VSS VDD VDD sky130_fd_sc_hd__decap_3
XFILLER_49_33 VSS VSS VDD VDD sky130_fd_sc_hd__decap_3
XFILLER_49_66 VSS VSS VDD VDD sky130_fd_sc_hd__decap_3
XPHY_EDGE_ROW_39_Left_97 VSS VSS VDD VDD sky130_fd_sc_hd__decap_3
XFILLER_41_340 VSS VSS VDD VDD sky130_fd_sc_hd__decap_3
XFILLER_45_134 VSS VSS VDD VDD sky130_fd_sc_hd__decap_3
XFILLER_14_80 VSS VSS VDD VDD sky130_fd_sc_hd__decap_3
XFILLER_46_6 VSS VSS VDD VDD sky130_fd_sc_hd__decap_3
X_1331_ net108 _0185_ net73 VSS VSS VDD VDD regs\[21\]\[1\] sky130_fd_sc_hd__dfrtp_1
X_1400_ net82 _0254_ net47 VSS VSS VDD VDD regs\[29\]\[6\] sky130_fd_sc_hd__dfrtp_1
XFILLER_36_167 VSS VSS VDD VDD sky130_fd_sc_hd__decap_3
X_1262_ net110 _0116_ net75 VSS VSS VDD VDD regs\[12\]\[4\] sky130_fd_sc_hd__dfrtp_1
Xinput6 clk VSS VSS VDD VDD net6 sky130_fd_sc_hd__buf_2
X_1193_ net88 _0047_ net53 VSS VSS VDD VDD regs\[3\]\[7\] sky130_fd_sc_hd__dfrtp_1
XFILLER_36_189 VSS VSS VDD VDD sky130_fd_sc_hd__decap_3
XFILLER_10_27 VSS VSS VDD VDD sky130_fd_sc_hd__fill_1
XFILLER_10_38 VSS VSS VDD VDD sky130_fd_sc_hd__decap_3
X_0977_ regs\[12\]\[1\] net40 _0566_ VSS VSS VDD VDD _0113_ sky130_fd_sc_hd__mux2_1
XFILLER_27_123 VSS VSS VDD VDD sky130_fd_sc_hd__decap_3
XFILLER_27_156 VSS VSS VDD VDD sky130_fd_sc_hd__decap_3
XFILLER_35_24 VSS VSS VDD VDD sky130_fd_sc_hd__decap_3
XFILLER_35_57 VSS VSS VDD VDD sky130_fd_sc_hd__decap_3
XFILLER_42_126 VSS VSS VDD VDD sky130_fd_sc_hd__decap_3
XFILLER_50_192 VSS VSS VDD VDD sky130_fd_sc_hd__decap_3
XFILLER_51_12 VSS VSS VDD VDD sky130_fd_sc_hd__decap_3
XFILLER_51_45 VSS VSS VDD VDD sky130_fd_sc_hd__decap_3
XFILLER_51_78 VSS VSS VDD VDD sky130_fd_sc_hd__decap_3
XPHY_EDGE_ROW_14_Right_14 VSS VSS VDD VDD sky130_fd_sc_hd__decap_3
XFILLER_2_244 VSS VSS VDD VDD sky130_fd_sc_hd__decap_3
XPHY_EDGE_ROW_23_Right_23 VSS VSS VDD VDD sky130_fd_sc_hd__decap_3
XFILLER_18_134 VSS VSS VDD VDD sky130_fd_sc_hd__decap_3
XFILLER_33_137 VSS VSS VDD VDD sky130_fd_sc_hd__decap_3
X_0900_ regs\[3\]\[5\] net160 _0557_ VSS VSS VDD VDD _0045_ sky130_fd_sc_hd__mux2_1
XTAP_TAPCELL_ROW_56_460 VSS VDD sky130_fd_sc_hd__tapvpwrvgnd_1
XPHY_EDGE_ROW_32_Right_32 VSS VSS VDD VDD sky130_fd_sc_hd__decap_3
X_0831_ net135 regs\[18\]\[6\] net35 VSS VSS VDD VDD _0520_ sky130_fd_sc_hd__and3_1
X_0762_ regs\[16\]\[4\] net26 _0342_ regs\[8\]\[4\] _0326_ VSS VSS VDD VDD _0453_
+ sky130_fd_sc_hd__a221o_1
X_0693_ net131 regs\[18\]\[2\] net35 VSS VSS VDD VDD _0386_ sky130_fd_sc_hd__and3_1
XFILLER_2_50 VSS VSS VDD VDD sky130_fd_sc_hd__decap_3
XFILLER_44_3 VSS VSS VDD VDD sky130_fd_sc_hd__decap_3
X_1314_ net89 _0168_ net54 VSS VSS VDD VDD regs\[19\]\[0\] sky130_fd_sc_hd__dfrtp_1
XPHY_EDGE_ROW_41_Right_41 VSS VSS VDD VDD sky130_fd_sc_hd__decap_3
XFILLER_24_159 VSS VSS VDD VDD sky130_fd_sc_hd__decap_3
XFILLER_2_83 VSS VSS VDD VDD sky130_fd_sc_hd__fill_1
XFILLER_2_94 VSS VSS VDD VDD sky130_fd_sc_hd__decap_3
X_1245_ net97 _0099_ net62 VSS VSS VDD VDD regs\[10\]\[3\] sky130_fd_sc_hd__dfrtp_1
X_1176_ net93 _0030_ net58 VSS VSS VDD VDD regs\[1\]\[6\] sky130_fd_sc_hd__dfrtp_1
XPHY_EDGE_ROW_50_Right_50 VSS VSS VDD VDD sky130_fd_sc_hd__decap_3
XFILLER_21_15 VSS VSS VDD VDD sky130_fd_sc_hd__decap_3
XFILLER_21_48 VSS VSS VDD VDD sky130_fd_sc_hd__decap_3
XFILLER_46_12 VSS VSS VDD VDD sky130_fd_sc_hd__decap_3
XFILLER_46_56 VSS VSS VDD VDD sky130_fd_sc_hd__decap_3
XFILLER_11_310 VSS VSS VDD VDD sky130_fd_sc_hd__decap_3
XFILLER_30_107 VSS VSS VDD VDD sky130_fd_sc_hd__decap_3
XTAP_TAPCELL_ROW_53_441 VSS VDD sky130_fd_sc_hd__tapvpwrvgnd_1
XFILLER_7_314 VSS VSS VDD VDD sky130_fd_sc_hd__fill_1
XFILLER_7_39 VSS VSS VDD VDD sky130_fd_sc_hd__decap_3
XFILLER_11_92 VSS VSS VDD VDD sky130_fd_sc_hd__decap_3
XFILLER_30_9 VSS VSS VDD VDD sky130_fd_sc_hd__decap_3
XFILLER_46_251 VSS VSS VDD VDD sky130_fd_sc_hd__fill_1
X_1030_ regs\[18\]\[0\] net45 _0572_ VSS VSS VDD VDD _0160_ sky130_fd_sc_hd__mux2_1
X_0814_ regs\[9\]\[6\] _0316_ _0500_ _0501_ _0502_ VSS VSS VDD VDD _0503_ sky130_fd_sc_hd__a2111o_1
XPHY_EDGE_ROW_26_Left_84 VSS VSS VDD VDD sky130_fd_sc_hd__decap_3
X_0745_ net135 regs\[30\]\[4\] net33 VSS VSS VDD VDD _0436_ sky130_fd_sc_hd__and3_1
X_0676_ net135 regs\[18\]\[1\] net35 VSS VSS VDD VDD _0370_ sky130_fd_sc_hd__and3_1
XPHY_EDGE_ROW_10_Left_68 VSS VSS VDD VDD sky130_fd_sc_hd__decap_3
X_1228_ net92 _0082_ net57 VSS VSS VDD VDD regs\[8\]\[2\] sky130_fd_sc_hd__dfrtp_1
XFILLER_16_15 VSS VSS VDD VDD sky130_fd_sc_hd__decap_3
XFILLER_37_284 VSS VSS VDD VDD sky130_fd_sc_hd__decap_3
XFILLER_52_265 VSS VSS VDD VDD sky130_fd_sc_hd__fill_2
XFILLER_52_276 VSS VSS VDD VDD sky130_fd_sc_hd__decap_3
X_1159_ net94 _0013_ net59 VSS VSS VDD VDD net22 sky130_fd_sc_hd__dfrtp_1
XTAP_TAPCELL_ROW_50_422 VSS VDD sky130_fd_sc_hd__tapvpwrvgnd_1
XFILLER_57_44 VSS VSS VDD VDD sky130_fd_sc_hd__decap_3
XTAP_TAPCELL_ROW_7_166 VSS VDD sky130_fd_sc_hd__tapvpwrvgnd_1
XFILLER_28_251 VSS VSS VDD VDD sky130_fd_sc_hd__fill_1
XFILLER_43_243 VSS VSS VDD VDD sky130_fd_sc_hd__decap_3
XFILLER_57_66 VSS VSS VDD VDD sky130_fd_sc_hd__decap_3
XFILLER_57_88 VSS VSS VDD VDD sky130_fd_sc_hd__decap_3
XFILLER_7_111 VSS VSS VDD VDD sky130_fd_sc_hd__fill_1
XFILLER_11_184 VSS VSS VDD VDD sky130_fd_sc_hd__fill_2
XFILLER_22_80 VSS VSS VDD VDD sky130_fd_sc_hd__decap_3
XFILLER_19_295 VSS VSS VDD VDD sky130_fd_sc_hd__decap_3
XFILLER_34_210 VSS VSS VDD VDD sky130_fd_sc_hd__decap_3
XFILLER_34_243 VSS VSS VDD VDD sky130_fd_sc_hd__decap_3
X_1013_ regs\[16\]\[1\] net42 _0570_ VSS VSS VDD VDD _0145_ sky130_fd_sc_hd__mux2_1
XFILLER_57_302 VSS VSS VDD VDD sky130_fd_sc_hd__decap_3
X_0728_ regs\[4\]\[3\] _0332_ _0417_ _0418_ _0419_ VSS VSS VDD VDD _0420_ sky130_fd_sc_hd__a2111o_1
X_0659_ regs\[5\]\[1\] _0291_ _0324_ regs\[19\]\[1\] VSS VSS VDD VDD _0353_ sky130_fd_sc_hd__a22o_1
XPHY_EDGE_ROW_4_Right_4 VSS VSS VDD VDD sky130_fd_sc_hd__decap_3
XFILLER_25_221 VSS VSS VDD VDD sky130_fd_sc_hd__decap_3
XFILLER_57_324 VSS VSS VDD VDD sky130_fd_sc_hd__decap_3
XTAP_TAPCELL_ROW_4_147 VSS VDD sky130_fd_sc_hd__tapvpwrvgnd_1
XFILLER_40_246 VSS VSS VDD VDD sky130_fd_sc_hd__fill_1
XFILLER_43_24 VSS VSS VDD VDD sky130_fd_sc_hd__decap_3
XFILLER_4_18 VSS VSS VDD VDD sky130_fd_sc_hd__decap_3
XFILLER_4_29 VSS VSS VDD VDD sky130_fd_sc_hd__decap_3
XFILLER_48_324 VSS VSS VDD VDD sky130_fd_sc_hd__decap_3
XTAP_TAPCELL_ROW_26_282 VSS VDD sky130_fd_sc_hd__tapvpwrvgnd_1
XFILLER_39_335 VSS VSS VDD VDD sky130_fd_sc_hd__fill_1
XFILLER_54_327 VSS VSS VDD VDD sky130_fd_sc_hd__decap_3
XTAP_TAPCELL_ROW_1_128 VSS VDD sky130_fd_sc_hd__tapvpwrvgnd_1
XFILLER_13_27 VSS VSS VDD VDD sky130_fd_sc_hd__decap_3
XFILLER_22_246 VSS VSS VDD VDD sky130_fd_sc_hd__decap_3
Xfanout39 net42 VSS VSS VDD VDD net39 sky130_fd_sc_hd__clkbuf_4
XFILLER_13_49 VSS VSS VDD VDD sky130_fd_sc_hd__decap_3
XFILLER_38_24 VSS VSS VDD VDD sky130_fd_sc_hd__decap_3
XFILLER_38_35 VSS VSS VDD VDD sky130_fd_sc_hd__decap_3
XFILLER_38_68 VSS VSS VDD VDD sky130_fd_sc_hd__decap_3
XPHY_EDGE_ROW_13_Left_71 VSS VSS VDD VDD sky130_fd_sc_hd__decap_3
XFILLER_8_9 VSS VSS VDD VDD sky130_fd_sc_hd__decap_3
XFILLER_54_56 VSS VSS VDD VDD sky130_fd_sc_hd__decap_3
XFILLER_13_268 VSS VSS VDD VDD sky130_fd_sc_hd__decap_3
XTAP_TAPCELL_ROW_23_263 VSS VDD sky130_fd_sc_hd__tapvpwrvgnd_1
XFILLER_0_150 VSS VSS VDD VDD sky130_fd_sc_hd__decap_3
XFILLER_0_172 VSS VSS VDD VDD sky130_fd_sc_hd__decap_3
XFILLER_48_121 VSS VSS VDD VDD sky130_fd_sc_hd__decap_3
X_0993_ net148 _0294_ VSS VSS VDD VDD _0568_ sky130_fd_sc_hd__and2_4
XTAP_TAPCELL_ROW_46_399 VSS VDD sky130_fd_sc_hd__tapvpwrvgnd_1
XFILLER_24_15 VSS VSS VDD VDD sky130_fd_sc_hd__decap_3
XFILLER_39_165 VSS VSS VDD VDD sky130_fd_sc_hd__decap_3
XFILLER_39_187 VSS VSS VDD VDD sky130_fd_sc_hd__decap_3
XTAP_TAPCELL_ROW_37_344 VSS VDD sky130_fd_sc_hd__tapvpwrvgnd_1
XFILLER_10_227 VSS VSS VDD VDD sky130_fd_sc_hd__fill_1
XTAP_TAPCELL_ROW_20_244 VSS VDD sky130_fd_sc_hd__tapvpwrvgnd_1
XFILLER_49_12 VSS VSS VDD VDD sky130_fd_sc_hd__decap_3
XFILLER_49_45 VSS VSS VDD VDD sky130_fd_sc_hd__decap_3
XFILLER_6_6 VSS VSS VDD VDD sky130_fd_sc_hd__decap_3
XFILLER_45_113 VSS VSS VDD VDD sky130_fd_sc_hd__decap_3
XFILLER_45_157 VSS VSS VDD VDD sky130_fd_sc_hd__decap_3
XFILLER_5_242 VSS VSS VDD VDD sky130_fd_sc_hd__decap_3
XFILLER_5_253 VSS VSS VDD VDD sky130_fd_sc_hd__decap_3
XFILLER_30_80 VSS VSS VDD VDD sky130_fd_sc_hd__decap_3
XFILLER_39_6 VSS VSS VDD VDD sky130_fd_sc_hd__decap_3
X_1261_ net87 _0115_ net52 VSS VSS VDD VDD regs\[12\]\[3\] sky130_fd_sc_hd__dfrtp_1
X_1330_ net106 _0184_ net71 VSS VSS VDD VDD regs\[21\]\[0\] sky130_fd_sc_hd__dfrtp_1
XFILLER_51_127 VSS VSS VDD VDD sky130_fd_sc_hd__decap_3
Xinput7 nrst VSS VSS VDD VDD net7 sky130_fd_sc_hd__buf_2
X_1192_ net104 _0046_ net69 VSS VSS VDD VDD regs\[3\]\[6\] sky130_fd_sc_hd__dfrtp_1
XFILLER_51_138 VSS VSS VDD VDD sky130_fd_sc_hd__decap_3
X_0976_ regs\[12\]\[0\] net43 _0566_ VSS VSS VDD VDD _0112_ sky130_fd_sc_hd__mux2_1
XFILLER_19_15 VSS VSS VDD VDD sky130_fd_sc_hd__decap_3
XFILLER_27_113 VSS VSS VDD VDD sky130_fd_sc_hd__decap_3
XFILLER_27_135 VSS VSS VDD VDD sky130_fd_sc_hd__decap_3
XPHY_EDGE_ROW_40_Left_98 VSS VSS VDD VDD sky130_fd_sc_hd__decap_3
XFILLER_23_341 VSS VSS VDD VDD sky130_fd_sc_hd__decap_3
XFILLER_35_36 VSS VSS VDD VDD sky130_fd_sc_hd__decap_3
XFILLER_35_69 VSS VSS VDD VDD sky130_fd_sc_hd__decap_3
XFILLER_42_105 VSS VSS VDD VDD sky130_fd_sc_hd__fill_1
XFILLER_50_160 VSS VSS VDD VDD sky130_fd_sc_hd__decap_3
XFILLER_51_24 VSS VSS VDD VDD sky130_fd_sc_hd__decap_3
XFILLER_51_57 VSS VSS VDD VDD sky130_fd_sc_hd__decap_3
XFILLER_4_3 VSS VSS VDD VDD sky130_fd_sc_hd__decap_3
XFILLER_33_105 VSS VSS VDD VDD sky130_fd_sc_hd__decap_3
XTAP_TAPCELL_ROW_56_461 VSS VDD sky130_fd_sc_hd__tapvpwrvgnd_1
XFILLER_41_160 VSS VSS VDD VDD sky130_fd_sc_hd__fill_2
X_0830_ net135 regs\[22\]\[6\] net32 VSS VSS VDD VDD _0519_ sky130_fd_sc_hd__and3_1
X_0761_ regs\[1\]\[4\] _0299_ _0338_ regs\[10\]\[4\] VSS VSS VDD VDD _0452_ sky130_fd_sc_hd__a22o_1
X_0692_ net132 regs\[17\]\[2\] _0278_ VSS VSS VDD VDD _0385_ sky130_fd_sc_hd__and3_1
XPHY_EDGE_ROW_47_Left_105 VSS VSS VDD VDD sky130_fd_sc_hd__decap_3
XFILLER_2_62 VSS VSS VDD VDD sky130_fd_sc_hd__decap_3
XFILLER_37_3 VSS VSS VDD VDD sky130_fd_sc_hd__decap_3
X_1244_ net108 _0098_ net73 VSS VSS VDD VDD regs\[10\]\[2\] sky130_fd_sc_hd__dfrtp_1
X_1313_ net110 _0167_ net75 VSS VSS VDD VDD regs\[18\]\[7\] sky130_fd_sc_hd__dfrtp_1
X_1175_ net91 _0029_ net56 VSS VSS VDD VDD regs\[1\]\[5\] sky130_fd_sc_hd__dfrtp_1
XPHY_EDGE_ROW_56_Left_114 VSS VSS VDD VDD sky130_fd_sc_hd__decap_3
XFILLER_20_333 VSS VSS VDD VDD sky130_fd_sc_hd__decap_3
XFILLER_21_27 VSS VSS VDD VDD sky130_fd_sc_hd__decap_3
X_0959_ regs\[10\]\[1\] net41 _0564_ VSS VSS VDD VDD _0097_ sky130_fd_sc_hd__mux2_1
XFILLER_46_24 VSS VSS VDD VDD sky130_fd_sc_hd__decap_3
XFILLER_46_35 VSS VSS VDD VDD sky130_fd_sc_hd__decap_3
XFILLER_47_219 VSS VSS VDD VDD sky130_fd_sc_hd__decap_3
XFILLER_55_230 VSS VSS VDD VDD sky130_fd_sc_hd__fill_2
XFILLER_55_252 VSS VSS VDD VDD sky130_fd_sc_hd__decap_3
Xmax_cap25 _0340_ VSS VSS VDD VDD net25 sky130_fd_sc_hd__clkbuf_2
XFILLER_15_149 VSS VSS VDD VDD sky130_fd_sc_hd__fill_2
XFILLER_23_160 VSS VSS VDD VDD sky130_fd_sc_hd__decap_3
XFILLER_23_193 VSS VSS VDD VDD sky130_fd_sc_hd__decap_3
XFILLER_30_119 VSS VSS VDD VDD sky130_fd_sc_hd__decap_3
XFILLER_7_18 VSS VSS VDD VDD sky130_fd_sc_hd__decap_3
XTAP_TAPCELL_ROW_53_442 VSS VDD sky130_fd_sc_hd__tapvpwrvgnd_1
XFILLER_23_9 VSS VSS VDD VDD sky130_fd_sc_hd__decap_3
XFILLER_36_90 VSS VSS VDD VDD sky130_fd_sc_hd__decap_3
XFILLER_46_230 VSS VSS VDD VDD sky130_fd_sc_hd__decap_3
XFILLER_46_296 VSS VSS VDD VDD sky130_fd_sc_hd__decap_3
XFILLER_14_160 VSS VSS VDD VDD sky130_fd_sc_hd__decap_3
XFILLER_14_193 VSS VSS VDD VDD sky130_fd_sc_hd__decap_3
Xinput10 wdata[2] VSS VSS VDD VDD net10 sky130_fd_sc_hd__buf_2
X_0813_ net122 regs\[17\]\[6\] net37 VSS VSS VDD VDD _0502_ sky130_fd_sc_hd__and3_1
X_0744_ net135 regs\[5\]\[4\] net34 VSS VSS VDD VDD _0435_ sky130_fd_sc_hd__and3b_1
X_0675_ net135 regs\[27\]\[1\] net31 VSS VSS VDD VDD _0369_ sky130_fd_sc_hd__and3_1
XFILLER_29_219 VSS VSS VDD VDD sky130_fd_sc_hd__decap_3
X_1227_ net95 _0081_ net60 VSS VSS VDD VDD regs\[8\]\[1\] sky130_fd_sc_hd__dfrtp_1
X_1158_ net94 _0012_ net59 VSS VSS VDD VDD net21 sky130_fd_sc_hd__dfrtp_1
XFILLER_16_27 VSS VSS VDD VDD sky130_fd_sc_hd__fill_1
XFILLER_32_15 VSS VSS VDD VDD sky130_fd_sc_hd__decap_3
X_1089_ regs\[24\]\[5\] net162 _0269_ VSS VSS VDD VDD _0213_ sky130_fd_sc_hd__mux2_1
XTAP_TAPCELL_ROW_50_423 VSS VDD sky130_fd_sc_hd__tapvpwrvgnd_1
XFILLER_20_185 VSS VSS VDD VDD sky130_fd_sc_hd__decap_3
XFILLER_57_12 VSS VSS VDD VDD sky130_fd_sc_hd__decap_3
XFILLER_57_78 VSS VSS VDD VDD sky130_fd_sc_hd__decap_3
XTAP_TAPCELL_ROW_7_167 VSS VDD sky130_fd_sc_hd__tapvpwrvgnd_1
XFILLER_28_296 VSS VSS VDD VDD sky130_fd_sc_hd__decap_3
XFILLER_43_200 VSS VSS VDD VDD sky130_fd_sc_hd__decap_3
XFILLER_43_222 VSS VSS VDD VDD sky130_fd_sc_hd__fill_2
XFILLER_11_141 VSS VSS VDD VDD sky130_fd_sc_hd__decap_3
XFILLER_43_288 VSS VSS VDD VDD sky130_fd_sc_hd__decap_3
XFILLER_7_123 VSS VSS VDD VDD sky130_fd_sc_hd__decap_3
XFILLER_7_167 VSS VSS VDD VDD sky130_fd_sc_hd__fill_1
XFILLER_21_6 VSS VSS VDD VDD sky130_fd_sc_hd__decap_3
X_1012_ regs\[16\]\[0\] net45 _0570_ VSS VSS VDD VDD _0144_ sky130_fd_sc_hd__mux2_1
XFILLER_34_288 VSS VSS VDD VDD sky130_fd_sc_hd__decap_3
X_0727_ net128 regs\[29\]\[3\] _0312_ VSS VSS VDD VDD _0419_ sky130_fd_sc_hd__and3_1
X_0658_ _0347_ _0348_ _0350_ _0351_ VSS VSS VDD VDD _0352_ sky130_fd_sc_hd__or4_1
X_0589_ net133 _0283_ VSS VSS VDD VDD _0284_ sky130_fd_sc_hd__and2b_4
XTAP_TAPCELL_ROW_4_148 VSS VDD sky130_fd_sc_hd__tapvpwrvgnd_1
XFILLER_25_200 VSS VSS VDD VDD sky130_fd_sc_hd__fill_1
XFILLER_27_15 VSS VSS VDD VDD sky130_fd_sc_hd__decap_3
XFILLER_40_225 VSS VSS VDD VDD sky130_fd_sc_hd__decap_3
XFILLER_43_36 VSS VSS VDD VDD sky130_fd_sc_hd__decap_3
XFILLER_0_321 VSS VSS VDD VDD sky130_fd_sc_hd__decap_3
XFILLER_4_137 VSS VSS VDD VDD sky130_fd_sc_hd__decap_3
XFILLER_0_343 VSS VSS VDD VDD sky130_fd_sc_hd__fill_1
XFILLER_16_233 VSS VSS VDD VDD sky130_fd_sc_hd__decap_3
XFILLER_16_288 VSS VSS VDD VDD sky130_fd_sc_hd__decap_3
XFILLER_31_214 VSS VSS VDD VDD sky130_fd_sc_hd__decap_3
XFILLER_31_258 VSS VSS VDD VDD sky130_fd_sc_hd__decap_3
XTAP_TAPCELL_ROW_26_283 VSS VDD sky130_fd_sc_hd__tapvpwrvgnd_1
XFILLER_39_303 VSS VSS VDD VDD sky130_fd_sc_hd__decap_3
XFILLER_54_339 VSS VSS VDD VDD sky130_fd_sc_hd__decap_3
XTAP_TAPCELL_ROW_1_129 VSS VDD sky130_fd_sc_hd__tapvpwrvgnd_1
XFILLER_13_39 VSS VSS VDD VDD sky130_fd_sc_hd__decap_3
XFILLER_22_203 VSS VSS VDD VDD sky130_fd_sc_hd__decap_3
XFILLER_22_225 VSS VSS VDD VDD sky130_fd_sc_hd__decap_3
Xfanout29 _0315_ VSS VSS VDD VDD net29 sky130_fd_sc_hd__buf_2
XFILLER_45_306 VSS VSS VDD VDD sky130_fd_sc_hd__decap_3
XFILLER_57_100 VSS VSS VDD VDD sky130_fd_sc_hd__decap_3
XFILLER_57_122 VSS VSS VDD VDD sky130_fd_sc_hd__decap_3
XFILLER_57_144 VSS VSS VDD VDD sky130_fd_sc_hd__decap_3
XFILLER_57_177 VSS VSS VDD VDD sky130_fd_sc_hd__fill_1
XFILLER_54_13 VSS VSS VDD VDD sky130_fd_sc_hd__decap_3
XFILLER_54_35 VSS VSS VDD VDD sky130_fd_sc_hd__decap_3
XFILLER_54_68 VSS VSS VDD VDD sky130_fd_sc_hd__decap_3
XTAP_TAPCELL_ROW_23_264 VSS VDD sky130_fd_sc_hd__tapvpwrvgnd_1
XFILLER_0_162 VSS VSS VDD VDD sky130_fd_sc_hd__decap_3
XFILLER_48_100 VSS VSS VDD VDD sky130_fd_sc_hd__decap_3
XFILLER_0_195 VSS VSS VDD VDD sky130_fd_sc_hd__fill_1
X_0992_ regs\[13\]\[7\] net151 _0567_ VSS VSS VDD VDD _0127_ sky130_fd_sc_hd__mux2_1
XFILLER_5_51 VSS VSS VDD VDD sky130_fd_sc_hd__decap_3
XFILLER_5_84 VSS VSS VDD VDD sky130_fd_sc_hd__fill_1
XFILLER_24_27 VSS VSS VDD VDD sky130_fd_sc_hd__fill_1
XFILLER_24_38 VSS VSS VDD VDD sky130_fd_sc_hd__decap_3
XFILLER_27_328 VSS VSS VDD VDD sky130_fd_sc_hd__fill_1
XTAP_TAPCELL_ROW_37_345 VSS VDD sky130_fd_sc_hd__tapvpwrvgnd_1
XFILLER_10_206 VSS VSS VDD VDD sky130_fd_sc_hd__decap_3
XFILLER_40_15 VSS VSS VDD VDD sky130_fd_sc_hd__decap_3
XTAP_TAPCELL_ROW_20_245 VSS VDD sky130_fd_sc_hd__tapvpwrvgnd_1
XFILLER_49_24 VSS VSS VDD VDD sky130_fd_sc_hd__decap_3
XFILLER_49_57 VSS VSS VDD VDD sky130_fd_sc_hd__decap_3
XFILLER_45_169 VSS VSS VDD VDD sky130_fd_sc_hd__decap_3
XFILLER_14_71 VSS VSS VDD VDD sky130_fd_sc_hd__decap_3
XFILLER_41_320 VSS VSS VDD VDD sky130_fd_sc_hd__decap_3
XFILLER_53_9 VSS VSS VDD VDD sky130_fd_sc_hd__decap_3
X_1260_ net108 _0114_ net73 VSS VSS VDD VDD regs\[12\]\[2\] sky130_fd_sc_hd__dfrtp_1
Xinput8 wdata[0] VSS VSS VDD VDD net8 sky130_fd_sc_hd__clkbuf_1
X_1191_ net91 _0045_ net56 VSS VSS VDD VDD regs\[3\]\[5\] sky130_fd_sc_hd__dfrtp_1
XFILLER_24_309 VSS VSS VDD VDD sky130_fd_sc_hd__decap_3
XFILLER_44_180 VSS VSS VDD VDD sky130_fd_sc_hd__decap_3
XFILLER_51_106 VSS VSS VDD VDD sky130_fd_sc_hd__decap_3
XTAP_TAPCELL_ROW_34_326 VSS VDD sky130_fd_sc_hd__tapvpwrvgnd_1
XFILLER_32_342 VSS VSS VDD VDD sky130_fd_sc_hd__fill_2
X_0975_ net149 _0335_ VSS VSS VDD VDD _0566_ sky130_fd_sc_hd__and2_4
XFILLER_10_18 VSS VSS VDD VDD sky130_fd_sc_hd__decap_3
XFILLER_10_29 VSS VSS VDD VDD sky130_fd_sc_hd__decap_3
XFILLER_19_27 VSS VSS VDD VDD sky130_fd_sc_hd__decap_3
XFILLER_27_103 VSS VSS VDD VDD sky130_fd_sc_hd__decap_3
XFILLER_27_147 VSS VSS VDD VDD sky130_fd_sc_hd__decap_3
XFILLER_35_15 VSS VSS VDD VDD sky130_fd_sc_hd__decap_3
X_1389_ net86 _0243_ net51 VSS VSS VDD VDD regs\[28\]\[3\] sky130_fd_sc_hd__dfrtp_1
XFILLER_50_150 VSS VSS VDD VDD sky130_fd_sc_hd__fill_1
XFILLER_51_36 VSS VSS VDD VDD sky130_fd_sc_hd__decap_3
XFILLER_51_69 VSS VSS VDD VDD sky130_fd_sc_hd__decap_3
XFILLER_18_158 VSS VSS VDD VDD sky130_fd_sc_hd__decap_3
XFILLER_26_180 VSS VSS VDD VDD sky130_fd_sc_hd__decap_3
XFILLER_33_128 VSS VSS VDD VDD sky130_fd_sc_hd__decap_3
XTAP_TAPCELL_ROW_56_462 VSS VDD sky130_fd_sc_hd__tapvpwrvgnd_1
X_0760_ net131 regs\[31\]\[4\] net38 _0450_ VSS VSS VDD VDD _0451_ sky130_fd_sc_hd__a31o_1
XFILLER_51_6 VSS VSS VDD VDD sky130_fd_sc_hd__decap_3
X_0691_ net132 regs\[31\]\[2\] _0276_ VSS VSS VDD VDD _0384_ sky130_fd_sc_hd__and3_1
XFILLER_2_41 VSS VSS VDD VDD sky130_fd_sc_hd__decap_3
XFILLER_2_74 VSS VSS VDD VDD sky130_fd_sc_hd__decap_3
XFILLER_2_85 VSS VSS VDD VDD sky130_fd_sc_hd__decap_3
XFILLER_49_261 VSS VSS VDD VDD sky130_fd_sc_hd__fill_2
XFILLER_49_272 VSS VSS VDD VDD sky130_fd_sc_hd__decap_3
X_1243_ net93 _0097_ net58 VSS VSS VDD VDD regs\[10\]\[1\] sky130_fd_sc_hd__dfrtp_1
X_1312_ net114 _0166_ net79 VSS VSS VDD VDD regs\[18\]\[6\] sky130_fd_sc_hd__dfrtp_1
X_1174_ net93 _0028_ net58 VSS VSS VDD VDD regs\[1\]\[4\] sky130_fd_sc_hd__dfrtp_1
XFILLER_24_139 VSS VSS VDD VDD sky130_fd_sc_hd__fill_1
XFILLER_21_39 VSS VSS VDD VDD sky130_fd_sc_hd__decap_3
X_0958_ regs\[10\]\[0\] net45 _0564_ VSS VSS VDD VDD _0096_ sky130_fd_sc_hd__mux2_1
X_0889_ net170 regs\[2\]\[3\] _0556_ VSS VSS VDD VDD _0035_ sky130_fd_sc_hd__mux2_1
XFILLER_46_47 VSS VSS VDD VDD sky130_fd_sc_hd__decap_3
Xmax_cap37 _0278_ VSS VSS VDD VDD net37 sky130_fd_sc_hd__clkbuf_2
XFILLER_23_172 VSS VSS VDD VDD sky130_fd_sc_hd__decap_3
XFILLER_7_305 VSS VSS VDD VDD sky130_fd_sc_hd__decap_3
XTAP_TAPCELL_ROW_53_443 VSS VDD sky130_fd_sc_hd__tapvpwrvgnd_1
XFILLER_16_9 VSS VSS VDD VDD sky130_fd_sc_hd__decap_3
XFILLER_46_242 VSS VSS VDD VDD sky130_fd_sc_hd__fill_1
XFILLER_46_253 VSS VSS VDD VDD sky130_fd_sc_hd__decap_3
XFILLER_46_275 VSS VSS VDD VDD sky130_fd_sc_hd__decap_3
Xinput11 wdata[3] VSS VSS VDD VDD net11 sky130_fd_sc_hd__buf_1
X_0812_ net121 regs\[28\]\[6\] net36 VSS VSS VDD VDD _0501_ sky130_fd_sc_hd__and3_1
X_0743_ net147 net20 _0433_ _0434_ VSS VSS VDD VDD _0011_ sky130_fd_sc_hd__a22o_1
X_0674_ regs\[14\]\[1\] _0294_ _0365_ _0366_ _0367_ VSS VSS VDD VDD _0368_ sky130_fd_sc_hd__a2111o_1
XFILLER_37_242 VSS VSS VDD VDD sky130_fd_sc_hd__decap_3
XFILLER_37_297 VSS VSS VDD VDD sky130_fd_sc_hd__decap_3
X_1226_ net86 _0080_ net51 VSS VSS VDD VDD regs\[8\]\[0\] sky130_fd_sc_hd__dfrtp_1
X_1157_ net97 _0011_ net62 VSS VSS VDD VDD net20 sky130_fd_sc_hd__dfrtp_1
XFILLER_20_131 VSS VSS VDD VDD sky130_fd_sc_hd__decap_3
XFILLER_32_27 VSS VSS VDD VDD sky130_fd_sc_hd__fill_1
XFILLER_32_38 VSS VSS VDD VDD sky130_fd_sc_hd__decap_3
XFILLER_52_256 VSS VSS VDD VDD sky130_fd_sc_hd__decap_3
X_1088_ regs\[24\]\[4\] net167 _0269_ VSS VSS VDD VDD _0212_ sky130_fd_sc_hd__mux2_1
XTAP_TAPCELL_ROW_50_424 VSS VDD sky130_fd_sc_hd__tapvpwrvgnd_1
XFILLER_57_24 VSS VSS VDD VDD sky130_fd_sc_hd__decap_3
XFILLER_57_35 VSS VSS VDD VDD sky130_fd_sc_hd__decap_3
XFILLER_57_57 VSS VSS VDD VDD sky130_fd_sc_hd__decap_3
XTAP_TAPCELL_ROW_7_168 VSS VDD sky130_fd_sc_hd__tapvpwrvgnd_1
XFILLER_43_234 VSS VSS VDD VDD sky130_fd_sc_hd__decap_3
XFILLER_43_267 VSS VSS VDD VDD sky130_fd_sc_hd__decap_3
XFILLER_11_175 VSS VSS VDD VDD sky130_fd_sc_hd__decap_3
XFILLER_22_71 VSS VSS VDD VDD sky130_fd_sc_hd__decap_3
XFILLER_7_102 VSS VSS VDD VDD sky130_fd_sc_hd__decap_3
XFILLER_7_113 VSS VSS VDD VDD sky130_fd_sc_hd__decap_3
XFILLER_7_135 VSS VSS VDD VDD sky130_fd_sc_hd__decap_3
XFILLER_14_6 VSS VSS VDD VDD sky130_fd_sc_hd__decap_3
XFILLER_19_220 VSS VSS VDD VDD sky130_fd_sc_hd__decap_3
XFILLER_19_231 VSS VSS VDD VDD sky130_fd_sc_hd__decap_3
XFILLER_34_201 VSS VSS VDD VDD sky130_fd_sc_hd__decap_3
XFILLER_34_234 VSS VSS VDD VDD sky130_fd_sc_hd__fill_1
X_1011_ net123 net148 net26 VSS VSS VDD VDD _0570_ sky130_fd_sc_hd__and3_4
XFILLER_6_190 VSS VSS VDD VDD sky130_fd_sc_hd__decap_3
X_0726_ net128 regs\[24\]\[3\] _0340_ VSS VSS VDD VDD _0418_ sky130_fd_sc_hd__and3_1
XFILLER_8_73 VSS VSS VDD VDD sky130_fd_sc_hd__fill_2
XFILLER_27_27 VSS VSS VDD VDD sky130_fd_sc_hd__decap_3
XFILLER_57_315 VSS VSS VDD VDD sky130_fd_sc_hd__decap_3
XFILLER_57_337 VSS VSS VDD VDD sky130_fd_sc_hd__decap_3
X_0657_ regs\[11\]\[1\] _0307_ _0336_ regs\[2\]\[1\] VSS VSS VDD VDD _0351_ sky130_fd_sc_hd__a22o_1
X_0588_ net141 net139 net143 net175 VSS VSS VDD VDD _0283_ sky130_fd_sc_hd__and4bb_1
XTAP_TAPCELL_ROW_4_149 VSS VDD sky130_fd_sc_hd__tapvpwrvgnd_1
XFILLER_25_234 VSS VSS VDD VDD sky130_fd_sc_hd__decap_3
XFILLER_43_15 VSS VSS VDD VDD sky130_fd_sc_hd__decap_3
X_1209_ net100 _0063_ net65 VSS VSS VDD VDD regs\[5\]\[7\] sky130_fd_sc_hd__dfrtp_1
XFILLER_43_48 VSS VSS VDD VDD sky130_fd_sc_hd__decap_3
XFILLER_0_333 VSS VSS VDD VDD sky130_fd_sc_hd__decap_3
XFILLER_16_245 VSS VSS VDD VDD sky130_fd_sc_hd__decap_3
XFILLER_17_60 VSS VSS VDD VDD sky130_fd_sc_hd__decap_3
XFILLER_12_3 VSS VSS VDD VDD sky130_fd_sc_hd__decap_3
XFILLER_39_326 VSS VSS VDD VDD sky130_fd_sc_hd__decap_3
XFILLER_39_337 VSS VSS VDD VDD sky130_fd_sc_hd__decap_3
XFILLER_54_318 VSS VSS VDD VDD sky130_fd_sc_hd__decap_3
XFILLER_13_18 VSS VSS VDD VDD sky130_fd_sc_hd__decap_3
XFILLER_22_237 VSS VSS VDD VDD sky130_fd_sc_hd__decap_3
XFILLER_22_259 VSS VSS VDD VDD sky130_fd_sc_hd__fill_2
XFILLER_1_108 VSS VSS VDD VDD sky130_fd_sc_hd__decap_3
XFILLER_1_119 VSS VSS VDD VDD sky130_fd_sc_hd__decap_3
X_0709_ regs\[15\]\[2\] _0281_ _0299_ regs\[1\]\[2\] VSS VSS VDD VDD _0402_ sky130_fd_sc_hd__a22o_1
XFILLER_38_15 VSS VSS VDD VDD sky130_fd_sc_hd__decap_3
XFILLER_45_329 VSS VSS VDD VDD sky130_fd_sc_hd__decap_3
XFILLER_57_134 VSS VSS VDD VDD sky130_fd_sc_hd__decap_3
XFILLER_57_167 VSS VSS VDD VDD sky130_fd_sc_hd__fill_1
XFILLER_13_215 VSS VSS VDD VDD sky130_fd_sc_hd__decap_3
XFILLER_13_248 VSS VSS VDD VDD sky130_fd_sc_hd__decap_3
XFILLER_53_340 VSS VSS VDD VDD sky130_fd_sc_hd__decap_3
XFILLER_54_25 VSS VSS VDD VDD sky130_fd_sc_hd__decap_3
XFILLER_54_47 VSS VSS VDD VDD sky130_fd_sc_hd__decap_3
XFILLER_9_219 VSS VSS VDD VDD sky130_fd_sc_hd__decap_3
XFILLER_21_281 VSS VSS VDD VDD sky130_fd_sc_hd__decap_3
XTAP_TAPCELL_ROW_23_265 VSS VDD sky130_fd_sc_hd__tapvpwrvgnd_1
XFILLER_0_141 VSS VSS VDD VDD sky130_fd_sc_hd__decap_3
XFILLER_48_112 VSS VSS VDD VDD sky130_fd_sc_hd__decap_3
XFILLER_28_81 VSS VSS VDD VDD sky130_fd_sc_hd__decap_3
XFILLER_36_307 VSS VSS VDD VDD sky130_fd_sc_hd__fill_1
XFILLER_48_156 VSS VSS VDD VDD sky130_fd_sc_hd__decap_3
XFILLER_12_292 VSS VSS VDD VDD sky130_fd_sc_hd__decap_3
XFILLER_44_80 VSS VSS VDD VDD sky130_fd_sc_hd__decap_3
XFILLER_44_91 VSS VSS VDD VDD sky130_fd_sc_hd__decap_3
XFILLER_8_263 VSS VSS VDD VDD sky130_fd_sc_hd__decap_3
X_0991_ regs\[13\]\[6\] net156 _0567_ VSS VSS VDD VDD _0126_ sky130_fd_sc_hd__mux2_1
XTAP_TAPCELL_ROW_14_210 VSS VDD sky130_fd_sc_hd__tapvpwrvgnd_1
XFILLER_5_30 VSS VSS VDD VDD sky130_fd_sc_hd__decap_3
XFILLER_27_307 VSS VSS VDD VDD sky130_fd_sc_hd__fill_1
XFILLER_39_178 VSS VSS VDD VDD sky130_fd_sc_hd__decap_3
XFILLER_50_343 VSS VSS VDD VDD sky130_fd_sc_hd__fill_1
XTAP_TAPCELL_ROW_37_346 VSS VDD sky130_fd_sc_hd__tapvpwrvgnd_1
XFILLER_10_218 VSS VSS VDD VDD sky130_fd_sc_hd__decap_3
XFILLER_40_27 VSS VSS VDD VDD sky130_fd_sc_hd__fill_1
XFILLER_40_38 VSS VSS VDD VDD sky130_fd_sc_hd__decap_3
XTAP_TAPCELL_ROW_20_246 VSS VDD sky130_fd_sc_hd__tapvpwrvgnd_1
XFILLER_49_36 VSS VSS VDD VDD sky130_fd_sc_hd__decap_3
XFILLER_49_69 VSS VSS VDD VDD sky130_fd_sc_hd__decap_3
XFILLER_18_307 VSS VSS VDD VDD sky130_fd_sc_hd__fill_1
XFILLER_45_137 VSS VSS VDD VDD sky130_fd_sc_hd__decap_3
XFILLER_14_83 VSS VSS VDD VDD sky130_fd_sc_hd__fill_1
XFILLER_14_94 VSS VSS VDD VDD sky130_fd_sc_hd__decap_3
XFILLER_41_343 VSS VSS VDD VDD sky130_fd_sc_hd__fill_1
XFILLER_30_71 VSS VSS VDD VDD sky130_fd_sc_hd__decap_3
XFILLER_46_9 VSS VSS VDD VDD sky130_fd_sc_hd__decap_3
Xinput9 wdata[1] VSS VSS VDD VDD net9 sky130_fd_sc_hd__clkbuf_1
X_1190_ net88 _0044_ net53 VSS VSS VDD VDD regs\[3\]\[4\] sky130_fd_sc_hd__dfrtp_1
XFILLER_32_321 VSS VSS VDD VDD sky130_fd_sc_hd__fill_1
XFILLER_44_192 VSS VSS VDD VDD sky130_fd_sc_hd__decap_3
XFILLER_55_90 VSS VSS VDD VDD sky130_fd_sc_hd__decap_3
XTAP_TAPCELL_ROW_34_327 VSS VDD sky130_fd_sc_hd__tapvpwrvgnd_1
X_0974_ regs\[11\]\[7\] net152 _0565_ VSS VSS VDD VDD _0111_ sky130_fd_sc_hd__mux2_1
XFILLER_27_126 VSS VSS VDD VDD sky130_fd_sc_hd__decap_3
XFILLER_27_159 VSS VSS VDD VDD sky130_fd_sc_hd__fill_1
XFILLER_35_27 VSS VSS VDD VDD sky130_fd_sc_hd__decap_3
X_1388_ net87 _0242_ net52 VSS VSS VDD VDD regs\[28\]\[2\] sky130_fd_sc_hd__dfrtp_1
XFILLER_50_195 VSS VSS VDD VDD sky130_fd_sc_hd__fill_1
XFILLER_51_15 VSS VSS VDD VDD sky130_fd_sc_hd__decap_3
XFILLER_51_48 VSS VSS VDD VDD sky130_fd_sc_hd__decap_3
XFILLER_2_203 VSS VSS VDD VDD sky130_fd_sc_hd__fill_1
XFILLER_2_247 VSS VSS VDD VDD sky130_fd_sc_hd__decap_3
XFILLER_18_137 VSS VSS VDD VDD sky130_fd_sc_hd__decap_3
XFILLER_25_60 VSS VSS VDD VDD sky130_fd_sc_hd__decap_3
XTAP_TAPCELL_ROW_56_463 VSS VDD sky130_fd_sc_hd__tapvpwrvgnd_1
XFILLER_25_82 VSS VSS VDD VDD sky130_fd_sc_hd__decap_3
XFILLER_25_93 VSS VSS VDD VDD sky130_fd_sc_hd__decap_3
X_0690_ regs\[26\]\[2\] _0301_ _0380_ _0381_ _0382_ VSS VSS VDD VDD _0383_ sky130_fd_sc_hd__a2111o_1
XTAP_TAPCELL_ROW_31_308 VSS VDD sky130_fd_sc_hd__tapvpwrvgnd_1
XFILLER_44_6 VSS VSS VDD VDD sky130_fd_sc_hd__decap_3
X_1311_ net115 _0165_ net80 VSS VSS VDD VDD regs\[18\]\[5\] sky130_fd_sc_hd__dfrtp_1
XFILLER_2_53 VSS VSS VDD VDD sky130_fd_sc_hd__decap_3
XFILLER_2_97 VSS VSS VDD VDD sky130_fd_sc_hd__decap_3
XFILLER_49_251 VSS VSS VDD VDD sky130_fd_sc_hd__fill_1
X_1242_ net98 _0096_ net63 VSS VSS VDD VDD regs\[10\]\[0\] sky130_fd_sc_hd__dfrtp_1
X_1173_ net88 _0027_ net53 VSS VSS VDD VDD regs\[1\]\[3\] sky130_fd_sc_hd__dfrtp_1
XPHY_EDGE_ROW_10_Right_10 VSS VSS VDD VDD sky130_fd_sc_hd__decap_3
XFILLER_20_313 VSS VSS VDD VDD sky130_fd_sc_hd__fill_2
XFILLER_21_18 VSS VSS VDD VDD sky130_fd_sc_hd__decap_3
X_0957_ net145 _0338_ VSS VSS VDD VDD _0564_ sky130_fd_sc_hd__and2_2
X_0888_ net174 regs\[2\]\[2\] _0556_ VSS VSS VDD VDD _0034_ sky130_fd_sc_hd__mux2_1
XFILLER_46_15 VSS VSS VDD VDD sky130_fd_sc_hd__decap_3
XFILLER_46_59 VSS VSS VDD VDD sky130_fd_sc_hd__fill_1
XTAP_TAPCELL_ROW_53_444 VSS VDD sky130_fd_sc_hd__tapvpwrvgnd_1
XFILLER_11_313 VSS VSS VDD VDD sky130_fd_sc_hd__fill_2
XFILLER_11_335 VSS VSS VDD VDD sky130_fd_sc_hd__fill_1
XFILLER_11_51 VSS VSS VDD VDD sky130_fd_sc_hd__decap_3
XFILLER_11_73 VSS VSS VDD VDD sky130_fd_sc_hd__decap_3
XFILLER_11_95 VSS VSS VDD VDD sky130_fd_sc_hd__decap_3
XFILLER_46_221 VSS VSS VDD VDD sky130_fd_sc_hd__decap_3
XFILLER_14_184 VSS VSS VDD VDD sky130_fd_sc_hd__decap_3
XFILLER_36_81 VSS VSS VDD VDD sky130_fd_sc_hd__decap_3
XFILLER_52_80 VSS VSS VDD VDD sky130_fd_sc_hd__decap_3
Xinput12 wdata[4] VSS VSS VDD VDD net12 sky130_fd_sc_hd__clkbuf_2
X_0811_ net125 regs\[21\]\[6\] net34 VSS VSS VDD VDD _0500_ sky130_fd_sc_hd__and3_1
X_0742_ regs\[0\]\[3\] _0327_ net147 VSS VSS VDD VDD _0434_ sky130_fd_sc_hd__o21ba_1
X_0673_ net126 regs\[31\]\[1\] net38 VSS VSS VDD VDD _0367_ sky130_fd_sc_hd__and3_1
XFILLER_16_18 VSS VSS VDD VDD sky130_fd_sc_hd__decap_3
XFILLER_16_29 VSS VSS VDD VDD sky130_fd_sc_hd__decap_3
XFILLER_37_287 VSS VSS VDD VDD sky130_fd_sc_hd__decap_3
X_1225_ net83 _0079_ net48 VSS VSS VDD VDD regs\[7\]\[7\] sky130_fd_sc_hd__dfrtp_1
X_1156_ net97 _0010_ net62 VSS VSS VDD VDD net19 sky130_fd_sc_hd__dfrtp_1
X_1087_ regs\[24\]\[3\] net169 _0269_ VSS VSS VDD VDD _0211_ sky130_fd_sc_hd__mux2_1
XFILLER_20_154 VSS VSS VDD VDD sky130_fd_sc_hd__decap_3
XFILLER_52_279 VSS VSS VDD VDD sky130_fd_sc_hd__decap_3
XTAP_TAPCELL_ROW_50_425 VSS VDD sky130_fd_sc_hd__tapvpwrvgnd_1
XFILLER_4_309 VSS VSS VDD VDD sky130_fd_sc_hd__decap_3
XFILLER_57_47 VSS VSS VDD VDD sky130_fd_sc_hd__decap_3
XFILLER_57_69 VSS VSS VDD VDD sky130_fd_sc_hd__decap_3
XTAP_TAPCELL_ROW_7_169 VSS VDD sky130_fd_sc_hd__tapvpwrvgnd_1
XFILLER_11_110 VSS VSS VDD VDD sky130_fd_sc_hd__fill_2
XFILLER_11_132 VSS VSS VDD VDD sky130_fd_sc_hd__decap_3
XFILLER_43_213 VSS VSS VDD VDD sky130_fd_sc_hd__decap_3
XFILLER_43_246 VSS VSS VDD VDD sky130_fd_sc_hd__decap_3
XFILLER_51_290 VSS VSS VDD VDD sky130_fd_sc_hd__decap_3
XFILLER_22_83 VSS VSS VDD VDD sky130_fd_sc_hd__fill_1
XFILLER_22_94 VSS VSS VDD VDD sky130_fd_sc_hd__decap_3
XFILLER_3_320 VSS VSS VDD VDD sky130_fd_sc_hd__decap_3
XFILLER_19_298 VSS VSS VDD VDD sky130_fd_sc_hd__decap_3
XFILLER_34_213 VSS VSS VDD VDD sky130_fd_sc_hd__decap_3
X_1010_ regs\[15\]\[7\] net154 _0569_ VSS VSS VDD VDD _0143_ sky130_fd_sc_hd__mux2_1
XFILLER_8_41 VSS VSS VDD VDD sky130_fd_sc_hd__decap_3
XFILLER_8_85 VSS VSS VDD VDD sky130_fd_sc_hd__decap_3
X_0725_ net127 regs\[25\]\[3\] net29 VSS VSS VDD VDD _0417_ sky130_fd_sc_hd__and3_1
X_0656_ net117 regs\[29\]\[1\] net30 _0349_ VSS VSS VDD VDD _0350_ sky130_fd_sc_hd__a31o_1
XFILLER_57_305 VSS VSS VDD VDD sky130_fd_sc_hd__decap_3
XFILLER_57_327 VSS VSS VDD VDD sky130_fd_sc_hd__decap_3
X_1208_ net111 _0062_ net76 VSS VSS VDD VDD regs\[5\]\[6\] sky130_fd_sc_hd__dfrtp_1
X_0587_ net126 regs\[15\]\[0\] net38 VSS VSS VDD VDD _0282_ sky130_fd_sc_hd__and3b_1
XFILLER_25_257 VSS VSS VDD VDD sky130_fd_sc_hd__decap_3
XFILLER_43_27 VSS VSS VDD VDD sky130_fd_sc_hd__decap_3
X_1139_ regs\[30\]\[1\] net42 _0275_ VSS VSS VDD VDD _0257_ sky130_fd_sc_hd__mux2_1
XFILLER_0_312 VSS VSS VDD VDD sky130_fd_sc_hd__decap_3
XFILLER_48_327 VSS VSS VDD VDD sky130_fd_sc_hd__decap_3
XFILLER_48_338 VSS VSS VDD VDD sky130_fd_sc_hd__decap_3
XFILLER_16_279 VSS VSS VDD VDD sky130_fd_sc_hd__decap_3
XFILLER_31_205 VSS VSS VDD VDD sky130_fd_sc_hd__decap_3
XFILLER_3_161 VSS VSS VDD VDD sky130_fd_sc_hd__decap_3
XFILLER_3_172 VSS VSS VDD VDD sky130_fd_sc_hd__decap_3
XFILLER_22_249 VSS VSS VDD VDD sky130_fd_sc_hd__decap_3
XPHY_EDGE_ROW_8_Right_8 VSS VSS VDD VDD sky130_fd_sc_hd__decap_3
XFILLER_15_290 VSS VSS VDD VDD sky130_fd_sc_hd__fill_1
XFILLER_38_27 VSS VSS VDD VDD sky130_fd_sc_hd__fill_1
X_0708_ regs\[2\]\[2\] _0336_ _0398_ _0399_ _0400_ VSS VSS VDD VDD _0401_ sky130_fd_sc_hd__a2111o_1
X_0639_ regs\[4\]\[0\] _0332_ _0333_ regs\[23\]\[0\] VSS VSS VDD VDD _0334_ sky130_fd_sc_hd__a22o_1
XPHY_EDGE_ROW_39_Right_39 VSS VSS VDD VDD sky130_fd_sc_hd__decap_3
XFILLER_38_38 VSS VSS VDD VDD sky130_fd_sc_hd__decap_3
XFILLER_57_113 VSS VSS VDD VDD sky130_fd_sc_hd__decap_3
XTAP_TAPCELL_ROW_0_120 VSS VDD sky130_fd_sc_hd__tapvpwrvgnd_1
XFILLER_54_59 VSS VSS VDD VDD sky130_fd_sc_hd__decap_3
XPHY_EDGE_ROW_48_Right_48 VSS VSS VDD VDD sky130_fd_sc_hd__decap_3
XPHY_EDGE_ROW_57_Right_57 VSS VSS VDD VDD sky130_fd_sc_hd__decap_3
XFILLER_0_131 VSS VSS VDD VDD sky130_fd_sc_hd__decap_3
XFILLER_0_153 VSS VSS VDD VDD sky130_fd_sc_hd__decap_3
XFILLER_0_175 VSS VSS VDD VDD sky130_fd_sc_hd__fill_2
XFILLER_0_186 VSS VSS VDD VDD sky130_fd_sc_hd__decap_3
XFILLER_0_197 VSS VSS VDD VDD sky130_fd_sc_hd__decap_3
XFILLER_48_124 VSS VSS VDD VDD sky130_fd_sc_hd__decap_3
XFILLER_48_168 VSS VSS VDD VDD sky130_fd_sc_hd__decap_3
XTAP_TAPCELL_ROW_14_211 VSS VDD sky130_fd_sc_hd__tapvpwrvgnd_1
XFILLER_8_253 VSS VSS VDD VDD sky130_fd_sc_hd__fill_2
X_0990_ regs\[13\]\[5\] net161 _0567_ VSS VSS VDD VDD _0125_ sky130_fd_sc_hd__mux2_1
XFILLER_5_42 VSS VSS VDD VDD sky130_fd_sc_hd__decap_3
XFILLER_35_341 VSS VSS VDD VDD sky130_fd_sc_hd__decap_3
XFILLER_39_113 VSS VSS VDD VDD sky130_fd_sc_hd__decap_3
XTAP_TAPCELL_ROW_37_347 VSS VDD sky130_fd_sc_hd__tapvpwrvgnd_1
XFILLER_24_18 VSS VSS VDD VDD sky130_fd_sc_hd__decap_3
XFILLER_24_29 VSS VSS VDD VDD sky130_fd_sc_hd__decap_3
XPHY_EDGE_ROW_17_Left_75 VSS VSS VDD VDD sky130_fd_sc_hd__decap_3
XTAP_TAPCELL_ROW_20_247 VSS VDD sky130_fd_sc_hd__tapvpwrvgnd_1
XFILLER_49_15 VSS VSS VDD VDD sky130_fd_sc_hd__decap_3
XFILLER_49_48 VSS VSS VDD VDD sky130_fd_sc_hd__decap_3
XFILLER_6_9 VSS VSS VDD VDD sky130_fd_sc_hd__decap_3
XFILLER_41_300 VSS VSS VDD VDD sky130_fd_sc_hd__decap_3
XFILLER_45_116 VSS VSS VDD VDD sky130_fd_sc_hd__decap_3
XFILLER_30_83 VSS VSS VDD VDD sky130_fd_sc_hd__fill_1
XFILLER_39_9 VSS VSS VDD VDD sky130_fd_sc_hd__decap_3
XFILLER_5_223 VSS VSS VDD VDD sky130_fd_sc_hd__fill_1
XFILLER_5_245 VSS VSS VDD VDD sky130_fd_sc_hd__fill_2
XFILLER_5_256 VSS VSS VDD VDD sky130_fd_sc_hd__fill_1
XFILLER_44_171 VSS VSS VDD VDD sky130_fd_sc_hd__decap_3
XTAP_TAPCELL_ROW_34_328 VSS VDD sky130_fd_sc_hd__tapvpwrvgnd_1
X_0973_ regs\[11\]\[6\] net157 _0565_ VSS VSS VDD VDD _0110_ sky130_fd_sc_hd__mux2_1
XFILLER_19_18 VSS VSS VDD VDD sky130_fd_sc_hd__decap_3
X_1387_ net103 _0241_ net68 VSS VSS VDD VDD regs\[28\]\[1\] sky130_fd_sc_hd__dfrtp_1
XFILLER_23_311 VSS VSS VDD VDD sky130_fd_sc_hd__fill_1
XFILLER_27_116 VSS VSS VDD VDD sky130_fd_sc_hd__fill_2
XFILLER_27_138 VSS VSS VDD VDD sky130_fd_sc_hd__decap_3
XFILLER_35_39 VSS VSS VDD VDD sky130_fd_sc_hd__decap_3
XFILLER_50_130 VSS VSS VDD VDD sky130_fd_sc_hd__decap_3
XFILLER_50_141 VSS VSS VDD VDD sky130_fd_sc_hd__decap_3
XFILLER_51_27 VSS VSS VDD VDD sky130_fd_sc_hd__decap_3
XFILLER_4_6 VSS VSS VDD VDD sky130_fd_sc_hd__decap_3
XFILLER_26_193 VSS VSS VDD VDD sky130_fd_sc_hd__decap_3
XFILLER_33_108 VSS VSS VDD VDD sky130_fd_sc_hd__decap_3
XTAP_TAPCELL_ROW_31_309 VSS VDD sky130_fd_sc_hd__tapvpwrvgnd_1
XFILLER_41_82 VSS VSS VDD VDD sky130_fd_sc_hd__decap_3
XFILLER_1_281 VSS VSS VDD VDD sky130_fd_sc_hd__decap_3
XFILLER_2_21 VSS VSS VDD VDD sky130_fd_sc_hd__decap_3
XFILLER_2_32 VSS VSS VDD VDD sky130_fd_sc_hd__decap_3
XFILLER_37_6 VSS VSS VDD VDD sky130_fd_sc_hd__decap_3
X_1241_ net88 _0095_ net53 VSS VSS VDD VDD regs\[9\]\[7\] sky130_fd_sc_hd__dfrtp_1
X_1310_ net111 _0164_ net76 VSS VSS VDD VDD regs\[18\]\[4\] sky130_fd_sc_hd__dfrtp_1
XFILLER_2_65 VSS VSS VDD VDD sky130_fd_sc_hd__decap_3
X_1172_ net96 _0026_ net61 VSS VSS VDD VDD regs\[1\]\[2\] sky130_fd_sc_hd__dfrtp_1
XFILLER_20_336 VSS VSS VDD VDD sky130_fd_sc_hd__decap_3
XFILLER_32_141 VSS VSS VDD VDD sky130_fd_sc_hd__fill_1
X_0956_ regs\[9\]\[7\] net152 _0563_ VSS VSS VDD VDD _0095_ sky130_fd_sc_hd__mux2_1
X_0887_ net41 regs\[2\]\[1\] _0556_ VSS VSS VDD VDD _0033_ sky130_fd_sc_hd__mux2_1
XFILLER_46_27 VSS VSS VDD VDD sky130_fd_sc_hd__fill_1
XFILLER_46_38 VSS VSS VDD VDD sky130_fd_sc_hd__decap_3
XFILLER_55_222 VSS VSS VDD VDD sky130_fd_sc_hd__fill_2
Xmax_cap28 _0319_ VSS VSS VDD VDD net28 sky130_fd_sc_hd__buf_1
XFILLER_15_119 VSS VSS VDD VDD sky130_fd_sc_hd__fill_1
XFILLER_23_163 VSS VSS VDD VDD sky130_fd_sc_hd__decap_3
XTAP_TAPCELL_ROW_53_445 VSS VDD sky130_fd_sc_hd__tapvpwrvgnd_1
XPHY_EDGE_ROW_43_Left_101 VSS VSS VDD VDD sky130_fd_sc_hd__decap_3
XFILLER_11_30 VSS VSS VDD VDD sky130_fd_sc_hd__decap_3
XFILLER_23_196 VSS VSS VDD VDD sky130_fd_sc_hd__decap_3
XPHY_EDGE_ROW_52_Left_110 VSS VSS VDD VDD sky130_fd_sc_hd__decap_3
XFILLER_2_3 VSS VSS VDD VDD sky130_fd_sc_hd__decap_3
XFILLER_36_60 VSS VSS VDD VDD sky130_fd_sc_hd__decap_3
XFILLER_36_71 VSS VSS VDD VDD sky130_fd_sc_hd__fill_1
XFILLER_46_233 VSS VSS VDD VDD sky130_fd_sc_hd__decap_3
XFILLER_46_299 VSS VSS VDD VDD sky130_fd_sc_hd__decap_3
XFILLER_14_141 VSS VSS VDD VDD sky130_fd_sc_hd__decap_3
XFILLER_14_163 VSS VSS VDD VDD sky130_fd_sc_hd__fill_2
XFILLER_36_93 VSS VSS VDD VDD sky130_fd_sc_hd__decap_3
Xinput13 wdata[5] VSS VSS VDD VDD net13 sky130_fd_sc_hd__clkbuf_2
X_0810_ regs\[2\]\[6\] _0336_ _0496_ _0497_ _0498_ VSS VSS VDD VDD _0499_ sky130_fd_sc_hd__a2111o_1
X_0741_ _0411_ _0416_ _0432_ VSS VSS VDD VDD _0433_ sky130_fd_sc_hd__or3_1
X_0672_ net132 regs\[26\]\[1\] _0300_ VSS VSS VDD VDD _0366_ sky130_fd_sc_hd__and3_1
XFILLER_35_3 VSS VSS VDD VDD sky130_fd_sc_hd__decap_3
XFILLER_37_222 VSS VSS VDD VDD sky130_fd_sc_hd__fill_2
XFILLER_37_233 VSS VSS VDD VDD sky130_fd_sc_hd__decap_3
X_1224_ net83 _0078_ net48 VSS VSS VDD VDD regs\[7\]\[6\] sky130_fd_sc_hd__dfrtp_1
X_1155_ net93 _0009_ net58 VSS VSS VDD VDD net18 sky130_fd_sc_hd__dfrtp_1
X_1086_ regs\[24\]\[2\] net174 _0269_ VSS VSS VDD VDD _0210_ sky130_fd_sc_hd__mux2_1
XFILLER_20_122 VSS VSS VDD VDD sky130_fd_sc_hd__decap_3
XFILLER_20_188 VSS VSS VDD VDD sky130_fd_sc_hd__decap_3
XFILLER_32_18 VSS VSS VDD VDD sky130_fd_sc_hd__decap_3
XFILLER_32_29 VSS VSS VDD VDD sky130_fd_sc_hd__decap_3
X_0939_ net148 _0342_ VSS VSS VDD VDD _0562_ sky130_fd_sc_hd__nand2_4
XTAP_TAPCELL_ROW_50_426 VSS VDD sky130_fd_sc_hd__tapvpwrvgnd_1
XFILLER_57_15 VSS VSS VDD VDD sky130_fd_sc_hd__decap_3
XFILLER_28_299 VSS VSS VDD VDD sky130_fd_sc_hd__decap_3
XFILLER_43_203 VSS VSS VDD VDD sky130_fd_sc_hd__decap_3
XFILLER_11_144 VSS VSS VDD VDD sky130_fd_sc_hd__decap_3
XFILLER_22_62 VSS VSS VDD VDD sky130_fd_sc_hd__fill_2
XFILLER_3_343 VSS VSS VDD VDD sky130_fd_sc_hd__fill_1
XFILLER_7_126 VSS VSS VDD VDD sky130_fd_sc_hd__decap_3
XPHY_EDGE_ROW_5_Left_63 VSS VSS VDD VDD sky130_fd_sc_hd__decap_3
XFILLER_21_9 VSS VSS VDD VDD sky130_fd_sc_hd__decap_3
XTAP_TAPCELL_ROW_12_194 VSS VDD sky130_fd_sc_hd__tapvpwrvgnd_1
XFILLER_6_181 VSS VSS VDD VDD sky130_fd_sc_hd__decap_3
X_0724_ _0412_ _0413_ _0414_ _0415_ VSS VSS VDD VDD _0416_ sky130_fd_sc_hd__or4_1
X_0655_ net117 regs\[25\]\[1\] net29 VSS VSS VDD VDD _0349_ sky130_fd_sc_hd__and3_1
X_0586_ net135 _0276_ VSS VSS VDD VDD _0281_ sky130_fd_sc_hd__and2b_2
XFILLER_27_18 VSS VSS VDD VDD sky130_fd_sc_hd__decap_3
X_1207_ net115 _0061_ net80 VSS VSS VDD VDD regs\[5\]\[5\] sky130_fd_sc_hd__dfrtp_1
XFILLER_40_228 VSS VSS VDD VDD sky130_fd_sc_hd__decap_3
XFILLER_43_39 VSS VSS VDD VDD sky130_fd_sc_hd__decap_3
X_1138_ regs\[30\]\[0\] net44 _0275_ VSS VSS VDD VDD _0256_ sky130_fd_sc_hd__mux2_1
X_1069_ regs\[22\]\[3\] net171 _0267_ VSS VSS VDD VDD _0195_ sky130_fd_sc_hd__mux2_1
XFILLER_0_302 VSS VSS VDD VDD sky130_fd_sc_hd__decap_3
XFILLER_0_324 VSS VSS VDD VDD sky130_fd_sc_hd__decap_3
XPHY_EDGE_ROW_31_Left_89 VSS VSS VDD VDD sky130_fd_sc_hd__decap_3
XFILLER_17_51 VSS VSS VDD VDD sky130_fd_sc_hd__decap_3
XFILLER_31_217 VSS VSS VDD VDD sky130_fd_sc_hd__decap_3
XTAP_TAPCELL_ROW_3_140 VSS VDD sky130_fd_sc_hd__tapvpwrvgnd_1
XFILLER_39_306 VSS VSS VDD VDD sky130_fd_sc_hd__decap_3
XFILLER_22_206 VSS VSS VDD VDD sky130_fd_sc_hd__decap_3
XFILLER_22_228 VSS VSS VDD VDD sky130_fd_sc_hd__decap_3
XFILLER_30_272 VSS VSS VDD VDD sky130_fd_sc_hd__decap_3
X_0707_ net125 regs\[5\]\[2\] net34 VSS VSS VDD VDD _0400_ sky130_fd_sc_hd__and3b_1
XFILLER_57_103 VSS VSS VDD VDD sky130_fd_sc_hd__decap_3
XFILLER_57_125 VSS VSS VDD VDD sky130_fd_sc_hd__decap_3
X_0638_ net129 _0303_ VSS VSS VDD VDD _0333_ sky130_fd_sc_hd__and2_2
XFILLER_13_206 VSS VSS VDD VDD sky130_fd_sc_hd__decap_3
XFILLER_45_309 VSS VSS VDD VDD sky130_fd_sc_hd__decap_3
XFILLER_53_331 VSS VSS VDD VDD sky130_fd_sc_hd__decap_3
XFILLER_54_16 VSS VSS VDD VDD sky130_fd_sc_hd__decap_3
XFILLER_54_38 VSS VSS VDD VDD sky130_fd_sc_hd__decap_3
XFILLER_57_147 VSS VSS VDD VDD sky130_fd_sc_hd__decap_3
XFILLER_57_169 VSS VSS VDD VDD sky130_fd_sc_hd__fill_2
XTAP_TAPCELL_ROW_0_121 VSS VDD sky130_fd_sc_hd__tapvpwrvgnd_1
XFILLER_0_165 VSS VSS VDD VDD sky130_fd_sc_hd__decap_3
XFILLER_36_309 VSS VSS VDD VDD sky130_fd_sc_hd__decap_3
XFILLER_48_103 VSS VSS VDD VDD sky130_fd_sc_hd__decap_3
XFILLER_5_21 VSS VSS VDD VDD sky130_fd_sc_hd__decap_3
XFILLER_39_125 VSS VSS VDD VDD sky130_fd_sc_hd__decap_3
XFILLER_5_54 VSS VSS VDD VDD sky130_fd_sc_hd__fill_2
XFILLER_39_169 VSS VSS VDD VDD sky130_fd_sc_hd__decap_3
XTAP_TAPCELL_ROW_37_348 VSS VDD sky130_fd_sc_hd__tapvpwrvgnd_1
XFILLER_10_209 VSS VSS VDD VDD sky130_fd_sc_hd__decap_3
XFILLER_40_18 VSS VSS VDD VDD sky130_fd_sc_hd__decap_3
XTAP_TAPCELL_ROW_45_392 VSS VDD sky130_fd_sc_hd__tapvpwrvgnd_1
XFILLER_40_29 VSS VSS VDD VDD sky130_fd_sc_hd__decap_3
XFILLER_49_27 VSS VSS VDD VDD sky130_fd_sc_hd__decap_3
XFILLER_26_342 VSS VSS VDD VDD sky130_fd_sc_hd__fill_2
XFILLER_41_323 VSS VSS VDD VDD sky130_fd_sc_hd__decap_3
XFILLER_45_128 VSS VSS VDD VDD sky130_fd_sc_hd__decap_3
XFILLER_14_41 VSS VSS VDD VDD sky130_fd_sc_hd__decap_3
XFILLER_14_74 VSS VSS VDD VDD sky130_fd_sc_hd__decap_3
XFILLER_36_139 VSS VSS VDD VDD sky130_fd_sc_hd__fill_1
XFILLER_39_93 VSS VSS VDD VDD sky130_fd_sc_hd__fill_2
XFILLER_51_109 VSS VSS VDD VDD sky130_fd_sc_hd__decap_3
XFILLER_55_81 VSS VSS VDD VDD sky130_fd_sc_hd__decap_3
XPHY_EDGE_ROW_34_Left_92 VSS VSS VDD VDD sky130_fd_sc_hd__decap_3
XFILLER_44_183 VSS VSS VDD VDD sky130_fd_sc_hd__decap_3
X_0972_ regs\[11\]\[5\] net160 _0565_ VSS VSS VDD VDD _0109_ sky130_fd_sc_hd__mux2_1
XTAP_TAPCELL_ROW_34_329 VSS VDD sky130_fd_sc_hd__tapvpwrvgnd_1
XFILLER_27_106 VSS VSS VDD VDD sky130_fd_sc_hd__decap_3
X_1386_ net101 _0240_ net66 VSS VSS VDD VDD regs\[28\]\[0\] sky130_fd_sc_hd__dfrtp_1
XFILLER_35_161 VSS VSS VDD VDD sky130_fd_sc_hd__decap_3
XFILLER_35_18 VSS VSS VDD VDD sky130_fd_sc_hd__decap_3
XFILLER_50_197 VSS VSS VDD VDD sky130_fd_sc_hd__decap_3
XFILLER_51_39 VSS VSS VDD VDD sky130_fd_sc_hd__decap_3
XFILLER_14_312 VSS VSS VDD VDD sky130_fd_sc_hd__decap_3
XFILLER_25_51 VSS VSS VDD VDD sky130_fd_sc_hd__decap_3
XFILLER_26_183 VSS VSS VDD VDD sky130_fd_sc_hd__decap_3
XFILLER_41_142 VSS VSS VDD VDD sky130_fd_sc_hd__decap_3
XFILLER_51_9 VSS VSS VDD VDD sky130_fd_sc_hd__decap_3
XFILLER_2_44 VSS VSS VDD VDD sky130_fd_sc_hd__decap_3
XFILLER_2_77 VSS VSS VDD VDD sky130_fd_sc_hd__decap_3
XFILLER_49_275 VSS VSS VDD VDD sky130_fd_sc_hd__decap_3
X_1240_ net102 _0094_ net67 VSS VSS VDD VDD regs\[9\]\[6\] sky130_fd_sc_hd__dfrtp_1
X_1171_ net93 _0025_ net58 VSS VSS VDD VDD regs\[1\]\[1\] sky130_fd_sc_hd__dfrtp_1
XFILLER_17_161 VSS VSS VDD VDD sky130_fd_sc_hd__decap_3
XFILLER_17_172 VSS VSS VDD VDD sky130_fd_sc_hd__fill_2
XFILLER_17_183 VSS VSS VDD VDD sky130_fd_sc_hd__decap_3
XFILLER_2_88 VSS VSS VDD VDD sky130_fd_sc_hd__decap_3
XFILLER_32_186 VSS VSS VDD VDD sky130_fd_sc_hd__decap_3
XFILLER_32_197 VSS VSS VDD VDD sky130_fd_sc_hd__decap_3
X_0955_ regs\[9\]\[6\] net158 _0563_ VSS VSS VDD VDD _0094_ sky130_fd_sc_hd__mux2_1
X_0886_ net43 regs\[2\]\[0\] _0556_ VSS VSS VDD VDD _0032_ sky130_fd_sc_hd__mux2_1
X_1369_ net88 _0223_ net53 VSS VSS VDD VDD regs\[25\]\[7\] sky130_fd_sc_hd__dfrtp_1
XFILLER_11_337 VSS VSS VDD VDD sky130_fd_sc_hd__decap_3
XFILLER_23_175 VSS VSS VDD VDD sky130_fd_sc_hd__decap_3
XFILLER_11_42 VSS VSS VDD VDD sky130_fd_sc_hd__decap_3
XFILLER_7_308 VSS VSS VDD VDD sky130_fd_sc_hd__decap_3
XFILLER_46_212 VSS VSS VDD VDD sky130_fd_sc_hd__decap_3
XFILLER_46_256 VSS VSS VDD VDD sky130_fd_sc_hd__fill_1
XFILLER_46_278 VSS VSS VDD VDD sky130_fd_sc_hd__decap_3
XFILLER_14_197 VSS VSS VDD VDD sky130_fd_sc_hd__decap_3
XFILLER_52_71 VSS VSS VDD VDD sky130_fd_sc_hd__decap_3
Xinput14 wdata[6] VSS VSS VDD VDD net14 sky130_fd_sc_hd__clkbuf_2
X_0740_ _0420_ _0423_ _0427_ _0431_ VSS VSS VDD VDD _0432_ sky130_fd_sc_hd__or4_1
X_0671_ net125 regs\[24\]\[1\] _0340_ VSS VSS VDD VDD _0365_ sky130_fd_sc_hd__and3_1
XFILLER_28_3 VSS VSS VDD VDD sky130_fd_sc_hd__decap_3
XFILLER_37_212 VSS VSS VDD VDD sky130_fd_sc_hd__fill_1
XFILLER_37_245 VSS VSS VDD VDD sky130_fd_sc_hd__fill_2
X_1223_ net91 _0077_ net56 VSS VSS VDD VDD regs\[7\]\[5\] sky130_fd_sc_hd__dfrtp_1
X_1154_ net97 _0008_ net62 VSS VSS VDD VDD net17 sky130_fd_sc_hd__dfrtp_1
XFILLER_20_101 VSS VSS VDD VDD sky130_fd_sc_hd__decap_3
XFILLER_37_267 VSS VSS VDD VDD sky130_fd_sc_hd__decap_3
XFILLER_52_259 VSS VSS VDD VDD sky130_fd_sc_hd__decap_3
X_1085_ regs\[24\]\[1\] net39 _0269_ VSS VSS VDD VDD _0209_ sky130_fd_sc_hd__mux2_1
XTAP_TAPCELL_ROW_50_427 VSS VDD sky130_fd_sc_hd__tapvpwrvgnd_1
XFILLER_20_134 VSS VSS VDD VDD sky130_fd_sc_hd__decap_3
X_0938_ regs\[7\]\[7\] net152 _0561_ VSS VSS VDD VDD _0079_ sky130_fd_sc_hd__mux2_1
X_0869_ net41 regs\[0\]\[1\] _0554_ VSS VSS VDD VDD _0017_ sky130_fd_sc_hd__mux2_1
XFILLER_57_27 VSS VSS VDD VDD sky130_fd_sc_hd__fill_1
XFILLER_57_38 VSS VSS VDD VDD sky130_fd_sc_hd__decap_3
XFILLER_43_237 VSS VSS VDD VDD sky130_fd_sc_hd__decap_3
XFILLER_11_101 VSS VSS VDD VDD sky130_fd_sc_hd__decap_3
XFILLER_11_123 VSS VSS VDD VDD sky130_fd_sc_hd__decap_3
XFILLER_11_178 VSS VSS VDD VDD sky130_fd_sc_hd__decap_3
XFILLER_51_281 VSS VSS VDD VDD sky130_fd_sc_hd__decap_3
XFILLER_7_105 VSS VSS VDD VDD sky130_fd_sc_hd__decap_3
XFILLER_7_116 VSS VSS VDD VDD sky130_fd_sc_hd__decap_3
XFILLER_7_138 VSS VSS VDD VDD sky130_fd_sc_hd__decap_3
XFILLER_22_74 VSS VSS VDD VDD sky130_fd_sc_hd__decap_3
XFILLER_3_311 VSS VSS VDD VDD sky130_fd_sc_hd__decap_3
XFILLER_14_9 VSS VSS VDD VDD sky130_fd_sc_hd__decap_3
XFILLER_19_223 VSS VSS VDD VDD sky130_fd_sc_hd__fill_1
XFILLER_19_234 VSS VSS VDD VDD sky130_fd_sc_hd__decap_3
XFILLER_47_60 VSS VSS VDD VDD sky130_fd_sc_hd__decap_3
XTAP_TAPCELL_ROW_6_160 VSS VDD sky130_fd_sc_hd__tapvpwrvgnd_1
XFILLER_19_289 VSS VSS VDD VDD sky130_fd_sc_hd__decap_3
XFILLER_34_204 VSS VSS VDD VDD sky130_fd_sc_hd__decap_3
XFILLER_42_292 VSS VSS VDD VDD sky130_fd_sc_hd__decap_3
XFILLER_8_21 VSS VSS VDD VDD sky130_fd_sc_hd__decap_3
XFILLER_8_32 VSS VSS VDD VDD sky130_fd_sc_hd__decap_3
X_0723_ regs\[26\]\[3\] _0301_ _0336_ regs\[2\]\[3\] VSS VSS VDD VDD _0415_ sky130_fd_sc_hd__a22o_1
XTAP_TAPCELL_ROW_12_195 VSS VDD sky130_fd_sc_hd__tapvpwrvgnd_1
XFILLER_57_318 VSS VSS VDD VDD sky130_fd_sc_hd__decap_3
XFILLER_6_193 VSS VSS VDD VDD sky130_fd_sc_hd__decap_3
X_0654_ regs\[3\]\[1\] _0284_ _0304_ regs\[7\]\[1\] VSS VSS VDD VDD _0348_ sky130_fd_sc_hd__a22o_1
X_0585_ net126 regs\[17\]\[0\] net37 VSS VSS VDD VDD _0280_ sky130_fd_sc_hd__and3_1
X_1206_ net115 _0060_ net80 VSS VSS VDD VDD regs\[5\]\[4\] sky130_fd_sc_hd__dfrtp_1
X_1137_ net130 net149 net33 VSS VSS VDD VDD _0275_ sky130_fd_sc_hd__and3_4
XFILLER_43_18 VSS VSS VDD VDD sky130_fd_sc_hd__decap_3
X_1068_ regs\[22\]\[2\] net172 _0267_ VSS VSS VDD VDD _0194_ sky130_fd_sc_hd__mux2_1
XTAP_TAPCELL_ROW_3_141 VSS VDD sky130_fd_sc_hd__tapvpwrvgnd_1
XFILLER_16_248 VSS VSS VDD VDD sky130_fd_sc_hd__decap_3
XFILLER_17_30 VSS VSS VDD VDD sky130_fd_sc_hd__decap_3
XFILLER_31_229 VSS VSS VDD VDD sky130_fd_sc_hd__decap_3
XFILLER_3_152 VSS VSS VDD VDD sky130_fd_sc_hd__decap_3
XFILLER_12_6 VSS VSS VDD VDD sky130_fd_sc_hd__decap_3
XFILLER_39_329 VSS VSS VDD VDD sky130_fd_sc_hd__decap_3
X_0706_ net121 regs\[9\]\[2\] net29 VSS VSS VDD VDD _0399_ sky130_fd_sc_hd__and3b_1
XFILLER_38_18 VSS VSS VDD VDD sky130_fd_sc_hd__decap_3
XFILLER_38_29 VSS VSS VDD VDD sky130_fd_sc_hd__decap_3
XFILLER_57_137 VSS VSS VDD VDD sky130_fd_sc_hd__decap_3
X_0637_ net133 _0319_ VSS VSS VDD VDD _0332_ sky130_fd_sc_hd__and2b_4
XFILLER_13_218 VSS VSS VDD VDD sky130_fd_sc_hd__decap_3
XFILLER_53_343 VSS VSS VDD VDD sky130_fd_sc_hd__fill_1
XTAP_TAPCELL_ROW_0_122 VSS VDD sky130_fd_sc_hd__tapvpwrvgnd_1
XFILLER_21_273 VSS VSS VDD VDD sky130_fd_sc_hd__decap_3
XFILLER_21_284 VSS VSS VDD VDD sky130_fd_sc_hd__fill_2
XFILLER_0_100 VSS VSS VDD VDD sky130_fd_sc_hd__decap_3
XFILLER_0_122 VSS VSS VDD VDD sky130_fd_sc_hd__decap_3
XFILLER_0_144 VSS VSS VDD VDD sky130_fd_sc_hd__decap_3
XFILLER_28_51 VSS VSS VDD VDD sky130_fd_sc_hd__decap_3
XFILLER_48_115 VSS VSS VDD VDD sky130_fd_sc_hd__decap_3
XFILLER_12_240 VSS VSS VDD VDD sky130_fd_sc_hd__decap_3
XFILLER_44_343 VSS VSS VDD VDD sky130_fd_sc_hd__fill_1
XFILLER_44_50 VSS VSS VDD VDD sky130_fd_sc_hd__decap_3
XFILLER_44_83 VSS VSS VDD VDD sky130_fd_sc_hd__fill_1
XFILLER_44_94 VSS VSS VDD VDD sky130_fd_sc_hd__decap_3
XFILLER_12_295 VSS VSS VDD VDD sky130_fd_sc_hd__fill_2
XFILLER_5_33 VSS VSS VDD VDD sky130_fd_sc_hd__decap_3
XFILLER_8_266 VSS VSS VDD VDD sky130_fd_sc_hd__decap_3
XFILLER_8_299 VSS VSS VDD VDD sky130_fd_sc_hd__decap_3
XFILLER_10_3 VSS VSS VDD VDD sky130_fd_sc_hd__decap_3
XFILLER_39_104 VSS VSS VDD VDD sky130_fd_sc_hd__decap_3
XFILLER_39_159 VSS VSS VDD VDD sky130_fd_sc_hd__decap_3
XFILLER_35_321 VSS VSS VDD VDD sky130_fd_sc_hd__decap_3
XFILLER_50_302 VSS VSS VDD VDD sky130_fd_sc_hd__decap_3
XTAP_TAPCELL_ROW_37_349 VSS VDD sky130_fd_sc_hd__tapvpwrvgnd_1
XTAP_TAPCELL_ROW_45_393 VSS VDD sky130_fd_sc_hd__tapvpwrvgnd_1
XFILLER_49_39 VSS VSS VDD VDD sky130_fd_sc_hd__decap_3
XFILLER_41_335 VSS VSS VDD VDD sky130_fd_sc_hd__fill_1
XFILLER_14_97 VSS VSS VDD VDD sky130_fd_sc_hd__decap_3
XFILLER_30_74 VSS VSS VDD VDD sky130_fd_sc_hd__decap_3
XFILLER_5_203 VSS VSS VDD VDD sky130_fd_sc_hd__decap_3
XFILLER_5_225 VSS VSS VDD VDD sky130_fd_sc_hd__decap_3
XFILLER_17_310 VSS VSS VDD VDD sky130_fd_sc_hd__fill_2
XFILLER_55_60 VSS VSS VDD VDD sky130_fd_sc_hd__decap_3
XFILLER_55_93 VSS VSS VDD VDD sky130_fd_sc_hd__fill_1
XFILLER_44_195 VSS VSS VDD VDD sky130_fd_sc_hd__fill_1
X_0971_ regs\[11\]\[4\] net165 _0565_ VSS VSS VDD VDD _0108_ sky130_fd_sc_hd__mux2_1
XTAP_TAPCELL_ROW_42_374 VSS VDD sky130_fd_sc_hd__tapvpwrvgnd_1
XFILLER_27_129 VSS VSS VDD VDD sky130_fd_sc_hd__decap_3
X_1385_ net84 _0239_ net49 VSS VSS VDD VDD regs\[27\]\[7\] sky130_fd_sc_hd__dfrtp_1
XFILLER_23_302 VSS VSS VDD VDD sky130_fd_sc_hd__decap_3
XFILLER_51_18 VSS VSS VDD VDD sky130_fd_sc_hd__decap_3
XFILLER_25_30 VSS VSS VDD VDD sky130_fd_sc_hd__decap_3
XFILLER_25_63 VSS VSS VDD VDD sky130_fd_sc_hd__decap_3
XFILLER_25_85 VSS VSS VDD VDD sky130_fd_sc_hd__fill_1
XFILLER_25_96 VSS VSS VDD VDD sky130_fd_sc_hd__decap_3
XFILLER_41_121 VSS VSS VDD VDD sky130_fd_sc_hd__decap_3
XFILLER_41_154 VSS VSS VDD VDD sky130_fd_sc_hd__decap_3
XFILLER_41_95 VSS VSS VDD VDD sky130_fd_sc_hd__fill_2
XFILLER_44_9 VSS VSS VDD VDD sky130_fd_sc_hd__decap_3
XFILLER_2_12 VSS VSS VDD VDD sky130_fd_sc_hd__decap_3
XFILLER_2_56 VSS VSS VDD VDD sky130_fd_sc_hd__decap_3
X_1170_ net83 _0024_ net48 VSS VSS VDD VDD regs\[1\]\[0\] sky130_fd_sc_hd__dfrtp_1
XFILLER_17_140 VSS VSS VDD VDD sky130_fd_sc_hd__decap_3
XFILLER_32_176 VSS VSS VDD VDD sky130_fd_sc_hd__decap_3
X_0954_ regs\[9\]\[5\] net161 _0563_ VSS VSS VDD VDD _0093_ sky130_fd_sc_hd__mux2_1
X_0885_ net148 _0336_ VSS VSS VDD VDD _0556_ sky130_fd_sc_hd__nand2_4
XFILLER_46_18 VSS VSS VDD VDD sky130_fd_sc_hd__decap_3
XFILLER_46_29 VSS VSS VDD VDD sky130_fd_sc_hd__decap_3
XFILLER_55_202 VSS VSS VDD VDD sky130_fd_sc_hd__decap_3
X_1299_ net109 _0153_ net74 VSS VSS VDD VDD regs\[17\]\[1\] sky130_fd_sc_hd__dfrtp_1
X_1368_ net85 _0222_ net50 VSS VSS VDD VDD regs\[25\]\[6\] sky130_fd_sc_hd__dfrtp_1
XFILLER_11_21 VSS VSS VDD VDD sky130_fd_sc_hd__decap_3
XFILLER_11_54 VSS VSS VDD VDD sky130_fd_sc_hd__fill_2
XFILLER_11_76 VSS VSS VDD VDD sky130_fd_sc_hd__decap_3
XFILLER_11_98 VSS VSS VDD VDD sky130_fd_sc_hd__decap_3
XFILLER_46_224 VSS VSS VDD VDD sky130_fd_sc_hd__decap_3
XFILLER_14_132 VSS VSS VDD VDD sky130_fd_sc_hd__decap_3
XFILLER_14_154 VSS VSS VDD VDD sky130_fd_sc_hd__decap_3
XFILLER_14_187 VSS VSS VDD VDD sky130_fd_sc_hd__decap_3
XFILLER_52_50 VSS VSS VDD VDD sky130_fd_sc_hd__decap_3
XFILLER_52_83 VSS VSS VDD VDD sky130_fd_sc_hd__fill_1
Xinput15 wdata[7] VSS VSS VDD VDD net15 sky130_fd_sc_hd__clkbuf_1
X_0670_ regs\[23\]\[1\] _0333_ _0362_ _0363_ _0326_ VSS VSS VDD VDD _0364_ sky130_fd_sc_hd__a2111o_1
XTAP_TAPCELL_ROW_9_180 VSS VDD sky130_fd_sc_hd__tapvpwrvgnd_1
XFILLER_37_279 VSS VSS VDD VDD sky130_fd_sc_hd__fill_1
X_1222_ net83 _0076_ net48 VSS VSS VDD VDD regs\[7\]\[4\] sky130_fd_sc_hd__dfrtp_1
X_1153_ net104 _0007_ net69 VSS VSS VDD VDD regs\[31\]\[7\] sky130_fd_sc_hd__dfrtp_1
X_1084_ regs\[24\]\[0\] net46 _0269_ VSS VSS VDD VDD _0208_ sky130_fd_sc_hd__mux2_1
XFILLER_20_146 VSS VSS VDD VDD sky130_fd_sc_hd__fill_2
XFILLER_20_157 VSS VSS VDD VDD sky130_fd_sc_hd__fill_1
X_0937_ regs\[7\]\[6\] net156 _0561_ VSS VSS VDD VDD _0078_ sky130_fd_sc_hd__mux2_1
X_0868_ net46 regs\[0\]\[0\] _0554_ VSS VSS VDD VDD _0016_ sky130_fd_sc_hd__mux2_1
X_0799_ net128 regs\[23\]\[5\] _0303_ VSS VSS VDD VDD _0489_ sky130_fd_sc_hd__and3_1
XFILLER_43_216 VSS VSS VDD VDD sky130_fd_sc_hd__decap_3
XFILLER_43_249 VSS VSS VDD VDD sky130_fd_sc_hd__decap_3
XFILLER_11_135 VSS VSS VDD VDD sky130_fd_sc_hd__decap_3
XFILLER_51_260 VSS VSS VDD VDD sky130_fd_sc_hd__fill_1
XFILLER_51_293 VSS VSS VDD VDD sky130_fd_sc_hd__decap_3
XFILLER_22_97 VSS VSS VDD VDD sky130_fd_sc_hd__fill_2
XFILLER_3_323 VSS VSS VDD VDD sky130_fd_sc_hd__fill_2
XFILLER_3_334 VSS VSS VDD VDD sky130_fd_sc_hd__fill_2
XFILLER_19_202 VSS VSS VDD VDD sky130_fd_sc_hd__fill_2
XFILLER_34_216 VSS VSS VDD VDD sky130_fd_sc_hd__fill_1
Xfanout170 net171 VSS VSS VDD VDD net170 sky130_fd_sc_hd__buf_2
XTAP_TAPCELL_ROW_6_161 VSS VDD sky130_fd_sc_hd__tapvpwrvgnd_1
XTAP_TAPCELL_ROW_29_296 VSS VDD sky130_fd_sc_hd__tapvpwrvgnd_1
XFILLER_6_150 VSS VSS VDD VDD sky130_fd_sc_hd__decap_3
XFILLER_8_44 VSS VSS VDD VDD sky130_fd_sc_hd__decap_3
X_0722_ regs\[17\]\[3\] _0279_ _0299_ regs\[1\]\[3\] VSS VSS VDD VDD _0414_ sky130_fd_sc_hd__a22o_1
X_0653_ regs\[1\]\[1\] _0299_ _0338_ regs\[10\]\[1\] VSS VSS VDD VDD _0347_ sky130_fd_sc_hd__a22o_1
XTAP_TAPCELL_ROW_12_196 VSS VDD sky130_fd_sc_hd__tapvpwrvgnd_1
XFILLER_8_88 VSS VSS VDD VDD sky130_fd_sc_hd__fill_2
XFILLER_40_3 VSS VSS VDD VDD sky130_fd_sc_hd__decap_3
X_0584_ net126 net37 VSS VSS VDD VDD _0279_ sky130_fd_sc_hd__and2_1
X_1205_ net112 _0059_ net77 VSS VSS VDD VDD regs\[5\]\[3\] sky130_fd_sc_hd__dfrtp_1
X_1136_ regs\[29\]\[7\] net151 _0274_ VSS VSS VDD VDD _0255_ sky130_fd_sc_hd__mux2_1
X_1067_ regs\[22\]\[1\] net40 _0267_ VSS VSS VDD VDD _0193_ sky130_fd_sc_hd__mux2_1
XFILLER_0_315 VSS VSS VDD VDD sky130_fd_sc_hd__decap_3
XFILLER_0_337 VSS VSS VDD VDD sky130_fd_sc_hd__decap_3
XFILLER_56_330 VSS VSS VDD VDD sky130_fd_sc_hd__decap_3
XTAP_TAPCELL_ROW_3_142 VSS VDD sky130_fd_sc_hd__tapvpwrvgnd_1
XFILLER_16_227 VSS VSS VDD VDD sky130_fd_sc_hd__decap_3
XFILLER_17_42 VSS VSS VDD VDD sky130_fd_sc_hd__decap_3
XFILLER_24_260 VSS VSS VDD VDD sky130_fd_sc_hd__decap_3
XFILLER_31_208 VSS VSS VDD VDD sky130_fd_sc_hd__decap_3
XFILLER_33_30 VSS VSS VDD VDD sky130_fd_sc_hd__decap_3
XFILLER_33_96 VSS VSS VDD VDD sky130_fd_sc_hd__decap_3
XFILLER_3_164 VSS VSS VDD VDD sky130_fd_sc_hd__decap_3
XFILLER_3_175 VSS VSS VDD VDD sky130_fd_sc_hd__fill_2
X_0705_ net121 regs\[28\]\[2\] net36 VSS VSS VDD VDD _0398_ sky130_fd_sc_hd__and3_1
X_0636_ _0321_ _0323_ _0328_ _0330_ VSS VSS VDD VDD _0331_ sky130_fd_sc_hd__or4_1
XFILLER_57_116 VSS VSS VDD VDD sky130_fd_sc_hd__decap_3
XFILLER_54_29 VSS VSS VDD VDD sky130_fd_sc_hd__decap_3
X_1119_ net127 net149 net36 VSS VSS VDD VDD _0273_ sky130_fd_sc_hd__and3_4
XTAP_TAPCELL_ROW_0_123 VSS VDD sky130_fd_sc_hd__tapvpwrvgnd_1
XPHY_EDGE_ROW_17_Right_17 VSS VSS VDD VDD sky130_fd_sc_hd__decap_3
XFILLER_0_134 VSS VSS VDD VDD sky130_fd_sc_hd__decap_3
XFILLER_0_156 VSS VSS VDD VDD sky130_fd_sc_hd__decap_3
XPHY_EDGE_ROW_26_Right_26 VSS VSS VDD VDD sky130_fd_sc_hd__decap_3
XFILLER_0_189 VSS VSS VDD VDD sky130_fd_sc_hd__decap_3
XFILLER_28_41 VSS VSS VDD VDD sky130_fd_sc_hd__fill_1
XFILLER_28_85 VSS VSS VDD VDD sky130_fd_sc_hd__decap_3
XFILLER_48_127 VSS VSS VDD VDD sky130_fd_sc_hd__decap_3
XPHY_EDGE_ROW_35_Right_35 VSS VSS VDD VDD sky130_fd_sc_hd__decap_3
XFILLER_5_12 VSS VSS VDD VDD sky130_fd_sc_hd__decap_3
XFILLER_5_45 VSS VSS VDD VDD sky130_fd_sc_hd__decap_3
XPHY_EDGE_ROW_44_Right_44 VSS VSS VDD VDD sky130_fd_sc_hd__decap_3
XTAP_TAPCELL_ROW_45_394 VSS VDD sky130_fd_sc_hd__tapvpwrvgnd_1
XPHY_EDGE_ROW_53_Right_53 VSS VSS VDD VDD sky130_fd_sc_hd__decap_3
XFILLER_49_18 VSS VSS VDD VDD sky130_fd_sc_hd__decap_3
X_0619_ net126 regs\[13\]\[0\] _0312_ VSS VSS VDD VDD _0314_ sky130_fd_sc_hd__and3b_1
XFILLER_26_333 VSS VSS VDD VDD sky130_fd_sc_hd__decap_3
XFILLER_53_141 VSS VSS VDD VDD sky130_fd_sc_hd__decap_3
XFILLER_14_21 VSS VSS VDD VDD sky130_fd_sc_hd__decap_3
XFILLER_14_32 VSS VSS VDD VDD sky130_fd_sc_hd__decap_3
XFILLER_41_303 VSS VSS VDD VDD sky130_fd_sc_hd__decap_3
XFILLER_30_53 VSS VSS VDD VDD sky130_fd_sc_hd__decap_3
XFILLER_39_51 VSS VSS VDD VDD sky130_fd_sc_hd__decap_3
XFILLER_44_130 VSS VSS VDD VDD sky130_fd_sc_hd__decap_3
XFILLER_44_141 VSS VSS VDD VDD sky130_fd_sc_hd__decap_3
XFILLER_44_174 VSS VSS VDD VDD sky130_fd_sc_hd__decap_3
XFILLER_55_72 VSS VSS VDD VDD sky130_fd_sc_hd__decap_3
X_0970_ regs\[11\]\[3\] net168 _0565_ VSS VSS VDD VDD _0107_ sky130_fd_sc_hd__mux2_1
XTAP_TAPCELL_ROW_42_375 VSS VDD sky130_fd_sc_hd__tapvpwrvgnd_1
X_1384_ net94 _0238_ net59 VSS VSS VDD VDD regs\[27\]\[6\] sky130_fd_sc_hd__dfrtp_1
XFILLER_50_133 VSS VSS VDD VDD sky130_fd_sc_hd__decap_3
XFILLER_50_144 VSS VSS VDD VDD sky130_fd_sc_hd__decap_3
XTAP_TAPCELL_ROW_33_320 VSS VDD sky130_fd_sc_hd__tapvpwrvgnd_1
XFILLER_4_9 VSS VSS VDD VDD sky130_fd_sc_hd__decap_3
XFILLER_25_42 VSS VSS VDD VDD sky130_fd_sc_hd__decap_3
XFILLER_41_111 VSS VSS VDD VDD sky130_fd_sc_hd__fill_1
XFILLER_41_133 VSS VSS VDD VDD sky130_fd_sc_hd__decap_3
XFILLER_41_30 VSS VSS VDD VDD sky130_fd_sc_hd__decap_3
XFILLER_41_52 VSS VSS VDD VDD sky130_fd_sc_hd__decap_3
XFILLER_37_9 VSS VSS VDD VDD sky130_fd_sc_hd__decap_3
XFILLER_41_85 VSS VSS VDD VDD sky130_fd_sc_hd__fill_1
XFILLER_1_284 VSS VSS VDD VDD sky130_fd_sc_hd__decap_3
XFILLER_2_24 VSS VSS VDD VDD sky130_fd_sc_hd__decap_3
XFILLER_2_35 VSS VSS VDD VDD sky130_fd_sc_hd__decap_3
XFILLER_2_68 VSS VSS VDD VDD sky130_fd_sc_hd__decap_3
XFILLER_49_211 VSS VSS VDD VDD sky130_fd_sc_hd__fill_1
XFILLER_49_222 VSS VSS VDD VDD sky130_fd_sc_hd__fill_2
XFILLER_17_152 VSS VSS VDD VDD sky130_fd_sc_hd__fill_1
XFILLER_20_306 VSS VSS VDD VDD sky130_fd_sc_hd__fill_2
XFILLER_20_339 VSS VSS VDD VDD sky130_fd_sc_hd__fill_1
X_0953_ regs\[9\]\[4\] net167 _0563_ VSS VSS VDD VDD _0092_ sky130_fd_sc_hd__mux2_1
X_0884_ net151 regs\[1\]\[7\] _0555_ VSS VSS VDD VDD _0031_ sky130_fd_sc_hd__mux2_1
X_1367_ net82 _0221_ net47 VSS VSS VDD VDD regs\[25\]\[5\] sky130_fd_sc_hd__dfrtp_1
XFILLER_55_225 VSS VSS VDD VDD sky130_fd_sc_hd__fill_1
XFILLER_55_269 VSS VSS VDD VDD sky130_fd_sc_hd__fill_2
X_1298_ net103 _0152_ net68 VSS VSS VDD VDD regs\[17\]\[0\] sky130_fd_sc_hd__dfrtp_1
XFILLER_23_133 VSS VSS VDD VDD sky130_fd_sc_hd__fill_1
XFILLER_23_166 VSS VSS VDD VDD sky130_fd_sc_hd__fill_2
XFILLER_23_199 VSS VSS VDD VDD sky130_fd_sc_hd__decap_3
XFILLER_11_33 VSS VSS VDD VDD sky130_fd_sc_hd__decap_3
XFILLER_2_6 VSS VSS VDD VDD sky130_fd_sc_hd__decap_3
XFILLER_46_203 VSS VSS VDD VDD sky130_fd_sc_hd__decap_3
XFILLER_46_236 VSS VSS VDD VDD sky130_fd_sc_hd__decap_3
XFILLER_14_122 VSS VSS VDD VDD sky130_fd_sc_hd__fill_1
XFILLER_14_144 VSS VSS VDD VDD sky130_fd_sc_hd__decap_3
XFILLER_36_63 VSS VSS VDD VDD sky130_fd_sc_hd__decap_3
XFILLER_36_96 VSS VSS VDD VDD sky130_fd_sc_hd__fill_2
XFILLER_52_62 VSS VSS VDD VDD sky130_fd_sc_hd__decap_3
Xinput16 we VSS VSS VDD VDD net16 sky130_fd_sc_hd__clkbuf_2
XFILLER_35_6 VSS VSS VDD VDD sky130_fd_sc_hd__decap_3
XFILLER_42_7 VSS VSS VDD VDD sky130_fd_sc_hd__decap_3
X_1221_ net92 _0075_ net57 VSS VSS VDD VDD regs\[7\]\[3\] sky130_fd_sc_hd__dfrtp_1
XTAP_TAPCELL_ROW_9_181 VSS VDD sky130_fd_sc_hd__tapvpwrvgnd_1
XFILLER_37_225 VSS VSS VDD VDD sky130_fd_sc_hd__fill_1
XFILLER_37_236 VSS VSS VDD VDD sky130_fd_sc_hd__decap_3
X_1152_ net106 _0006_ net71 VSS VSS VDD VDD regs\[31\]\[6\] sky130_fd_sc_hd__dfrtp_1
X_1083_ net128 net149 _0340_ VSS VSS VDD VDD _0269_ sky130_fd_sc_hd__and3_4
XFILLER_20_125 VSS VSS VDD VDD sky130_fd_sc_hd__decap_3
X_0936_ regs\[7\]\[5\] net160 _0561_ VSS VSS VDD VDD _0077_ sky130_fd_sc_hd__mux2_1
X_0867_ net146 _0326_ VSS VSS VDD VDD _0554_ sky130_fd_sc_hd__nand2_4
X_0798_ regs\[14\]\[5\] _0294_ _0485_ _0486_ _0487_ VSS VSS VDD VDD _0488_ sky130_fd_sc_hd__a2111o_1
XFILLER_28_225 VSS VSS VDD VDD sky130_fd_sc_hd__decap_3
XFILLER_57_18 VSS VSS VDD VDD sky130_fd_sc_hd__decap_3
XFILLER_57_29 VSS VSS VDD VDD sky130_fd_sc_hd__decap_3
XFILLER_43_206 VSS VSS VDD VDD sky130_fd_sc_hd__fill_2
XFILLER_11_147 VSS VSS VDD VDD sky130_fd_sc_hd__fill_1
XFILLER_11_169 VSS VSS VDD VDD sky130_fd_sc_hd__decap_3
XFILLER_22_21 VSS VSS VDD VDD sky130_fd_sc_hd__decap_3
XFILLER_22_32 VSS VSS VDD VDD sky130_fd_sc_hd__decap_3
XFILLER_3_302 VSS VSS VDD VDD sky130_fd_sc_hd__decap_3
XFILLER_7_129 VSS VSS VDD VDD sky130_fd_sc_hd__decap_3
XFILLER_0_3 VSS VSS VDD VDD sky130_fd_sc_hd__decap_3
XFILLER_19_225 VSS VSS VDD VDD sky130_fd_sc_hd__decap_3
XFILLER_47_51 VSS VSS VDD VDD sky130_fd_sc_hd__decap_3
Xfanout160 net161 VSS VSS VDD VDD net160 sky130_fd_sc_hd__buf_2
Xfanout171 net11 VSS VSS VDD VDD net171 sky130_fd_sc_hd__clkbuf_2
XTAP_TAPCELL_ROW_6_162 VSS VDD sky130_fd_sc_hd__tapvpwrvgnd_1
XFILLER_42_250 VSS VSS VDD VDD sky130_fd_sc_hd__fill_2
XFILLER_8_12 VSS VSS VDD VDD sky130_fd_sc_hd__decap_3
XTAP_TAPCELL_ROW_29_297 VSS VDD sky130_fd_sc_hd__tapvpwrvgnd_1
XFILLER_6_184 VSS VSS VDD VDD sky130_fd_sc_hd__decap_3
X_0721_ net124 regs\[18\]\[3\] net35 _0297_ regs\[6\]\[3\] VSS VSS VDD VDD _0413_
+ sky130_fd_sc_hd__a32o_1
X_0652_ net146 net17 _0345_ _0346_ VSS VSS VDD VDD _0008_ sky130_fd_sc_hd__a22o_1
X_0583_ net143 net141 net139 net175 VSS VSS VDD VDD _0278_ sky130_fd_sc_hd__nor4b_2
XTAP_TAPCELL_ROW_12_197 VSS VDD sky130_fd_sc_hd__tapvpwrvgnd_1
XFILLER_33_3 VSS VSS VDD VDD sky130_fd_sc_hd__decap_3
XFILLER_57_309 VSS VSS VDD VDD sky130_fd_sc_hd__decap_3
X_1204_ net100 _0058_ net65 VSS VSS VDD VDD regs\[5\]\[2\] sky130_fd_sc_hd__dfrtp_1
XFILLER_40_209 VSS VSS VDD VDD sky130_fd_sc_hd__fill_2
X_1135_ regs\[29\]\[6\] net156 _0274_ VSS VSS VDD VDD _0254_ sky130_fd_sc_hd__mux2_1
X_1066_ regs\[22\]\[0\] net43 _0267_ VSS VSS VDD VDD _0192_ sky130_fd_sc_hd__mux2_1
X_0919_ regs\[5\]\[6\] net158 _0559_ VSS VSS VDD VDD _0062_ sky130_fd_sc_hd__mux2_1
XFILLER_0_305 VSS VSS VDD VDD sky130_fd_sc_hd__decap_3
XFILLER_0_327 VSS VSS VDD VDD sky130_fd_sc_hd__decap_3
XFILLER_16_206 VSS VSS VDD VDD sky130_fd_sc_hd__fill_1
XFILLER_17_21 VSS VSS VDD VDD sky130_fd_sc_hd__decap_3
XFILLER_17_54 VSS VSS VDD VDD sky130_fd_sc_hd__fill_2
XFILLER_48_309 VSS VSS VDD VDD sky130_fd_sc_hd__decap_3
XFILLER_56_342 VSS VSS VDD VDD sky130_fd_sc_hd__fill_2
XTAP_TAPCELL_ROW_3_143 VSS VDD sky130_fd_sc_hd__tapvpwrvgnd_1
XFILLER_24_250 VSS VSS VDD VDD sky130_fd_sc_hd__fill_2
XFILLER_24_272 VSS VSS VDD VDD sky130_fd_sc_hd__decap_3
XFILLER_33_42 VSS VSS VDD VDD sky130_fd_sc_hd__decap_3
XFILLER_33_53 VSS VSS VDD VDD sky130_fd_sc_hd__decap_3
XFILLER_33_75 VSS VSS VDD VDD sky130_fd_sc_hd__fill_1
XTAP_TAPCELL_ROW_26_278 VSS VDD sky130_fd_sc_hd__tapvpwrvgnd_1
XPHY_EDGE_ROW_9_Left_67 VSS VSS VDD VDD sky130_fd_sc_hd__decap_3
XFILLER_3_110 VSS VSS VDD VDD sky130_fd_sc_hd__fill_2
XFILLER_39_309 VSS VSS VDD VDD sky130_fd_sc_hd__fill_2
XFILLER_22_209 VSS VSS VDD VDD sky130_fd_sc_hd__decap_3
XFILLER_47_342 VSS VSS VDD VDD sky130_fd_sc_hd__fill_2
XFILLER_30_253 VSS VSS VDD VDD sky130_fd_sc_hd__decap_3
XFILLER_30_275 VSS VSS VDD VDD sky130_fd_sc_hd__decap_3
X_0704_ _0393_ _0394_ _0395_ _0396_ VSS VSS VDD VDD _0397_ sky130_fd_sc_hd__or4_1
X_0635_ net121 regs\[29\]\[0\] _0312_ _0329_ VSS VSS VDD VDD _0330_ sky130_fd_sc_hd__a31o_1
XFILLER_53_301 VSS VSS VDD VDD sky130_fd_sc_hd__decap_3
XFILLER_54_19 VSS VSS VDD VDD sky130_fd_sc_hd__decap_3
XFILLER_57_106 VSS VSS VDD VDD sky130_fd_sc_hd__decap_3
XFILLER_57_128 VSS VSS VDD VDD sky130_fd_sc_hd__decap_3
XTAP_TAPCELL_ROW_0_124 VSS VDD sky130_fd_sc_hd__tapvpwrvgnd_1
XFILLER_13_209 VSS VSS VDD VDD sky130_fd_sc_hd__decap_3
XFILLER_21_220 VSS VSS VDD VDD sky130_fd_sc_hd__decap_3
XFILLER_53_334 VSS VSS VDD VDD sky130_fd_sc_hd__fill_2
X_1118_ regs\[27\]\[7\] net152 _0272_ VSS VSS VDD VDD _0239_ sky130_fd_sc_hd__mux2_1
X_1049_ regs\[20\]\[1\] net40 _0265_ VSS VSS VDD VDD _0177_ sky130_fd_sc_hd__mux2_1
XFILLER_0_113 VSS VSS VDD VDD sky130_fd_sc_hd__decap_3
XFILLER_48_106 VSS VSS VDD VDD sky130_fd_sc_hd__decap_3
XFILLER_48_139 VSS VSS VDD VDD sky130_fd_sc_hd__fill_1
XFILLER_28_97 VSS VSS VDD VDD sky130_fd_sc_hd__decap_3
XFILLER_44_41 VSS VSS VDD VDD sky130_fd_sc_hd__decap_3
XFILLER_44_85 VSS VSS VDD VDD sky130_fd_sc_hd__decap_3
XFILLER_5_24 VSS VSS VDD VDD sky130_fd_sc_hd__decap_3
XFILLER_39_128 VSS VSS VDD VDD sky130_fd_sc_hd__fill_2
XTAP_TAPCELL_ROW_45_395 VSS VDD sky130_fd_sc_hd__tapvpwrvgnd_1
XFILLER_7_290 VSS VSS VDD VDD sky130_fd_sc_hd__decap_3
X_0618_ net121 _0312_ VSS VSS VDD VDD _0313_ sky130_fd_sc_hd__and2b_1
XFILLER_53_120 VSS VSS VDD VDD sky130_fd_sc_hd__decap_3
XTAP_TAPCELL_ROW_36_340 VSS VDD sky130_fd_sc_hd__tapvpwrvgnd_1
XFILLER_14_77 VSS VSS VDD VDD sky130_fd_sc_hd__decap_3
XFILLER_41_326 VSS VSS VDD VDD sky130_fd_sc_hd__decap_3
XFILLER_41_337 VSS VSS VDD VDD sky130_fd_sc_hd__decap_3
XFILLER_30_21 VSS VSS VDD VDD sky130_fd_sc_hd__decap_3
XFILLER_30_32 VSS VSS VDD VDD sky130_fd_sc_hd__fill_1
XFILLER_30_65 VSS VSS VDD VDD sky130_fd_sc_hd__decap_3
XFILLER_17_301 VSS VSS VDD VDD sky130_fd_sc_hd__decap_3
XFILLER_29_161 VSS VSS VDD VDD sky130_fd_sc_hd__decap_3
XFILLER_39_30 VSS VSS VDD VDD sky130_fd_sc_hd__decap_3
XFILLER_32_304 VSS VSS VDD VDD sky130_fd_sc_hd__decap_3
XFILLER_44_186 VSS VSS VDD VDD sky130_fd_sc_hd__decap_3
XFILLER_55_51 VSS VSS VDD VDD sky130_fd_sc_hd__decap_3
XFILLER_55_84 VSS VSS VDD VDD sky130_fd_sc_hd__decap_3
XTAP_TAPCELL_ROW_42_376 VSS VDD sky130_fd_sc_hd__tapvpwrvgnd_1
XFILLER_4_271 VSS VSS VDD VDD sky130_fd_sc_hd__decap_3
X_1383_ net93 _0237_ net58 VSS VSS VDD VDD regs\[27\]\[5\] sky130_fd_sc_hd__dfrtp_1
XFILLER_27_109 VSS VSS VDD VDD sky130_fd_sc_hd__decap_3
XFILLER_35_164 VSS VSS VDD VDD sky130_fd_sc_hd__decap_3
XFILLER_50_189 VSS VSS VDD VDD sky130_fd_sc_hd__decap_3
XTAP_TAPCELL_ROW_33_321 VSS VDD sky130_fd_sc_hd__tapvpwrvgnd_1
XFILLER_14_315 VSS VSS VDD VDD sky130_fd_sc_hd__fill_1
XFILLER_25_21 VSS VSS VDD VDD sky130_fd_sc_hd__decap_3
XFILLER_25_54 VSS VSS VDD VDD sky130_fd_sc_hd__fill_2
XFILLER_25_76 VSS VSS VDD VDD sky130_fd_sc_hd__decap_3
XFILLER_26_120 VSS VSS VDD VDD sky130_fd_sc_hd__decap_3
XFILLER_26_186 VSS VSS VDD VDD sky130_fd_sc_hd__fill_1
XFILLER_26_197 VSS VSS VDD VDD sky130_fd_sc_hd__fill_2
XFILLER_41_145 VSS VSS VDD VDD sky130_fd_sc_hd__decap_3
XFILLER_41_42 VSS VSS VDD VDD sky130_fd_sc_hd__decap_3
XPHY_EDGE_ROW_38_Left_96 VSS VSS VDD VDD sky130_fd_sc_hd__decap_3
XFILLER_17_131 VSS VSS VDD VDD sky130_fd_sc_hd__decap_3
XFILLER_17_164 VSS VSS VDD VDD sky130_fd_sc_hd__decap_3
XFILLER_2_47 VSS VSS VDD VDD sky130_fd_sc_hd__decap_3
XFILLER_49_234 VSS VSS VDD VDD sky130_fd_sc_hd__decap_3
XFILLER_49_278 VSS VSS VDD VDD sky130_fd_sc_hd__fill_2
XFILLER_17_186 VSS VSS VDD VDD sky130_fd_sc_hd__fill_1
XFILLER_32_189 VSS VSS VDD VDD sky130_fd_sc_hd__fill_2
X_0952_ regs\[9\]\[3\] net168 _0563_ VSS VSS VDD VDD _0091_ sky130_fd_sc_hd__mux2_1
XTAP_TAPCELL_ROW_30_302 VSS VDD sky130_fd_sc_hd__tapvpwrvgnd_1
X_0883_ net156 regs\[1\]\[6\] _0555_ VSS VSS VDD VDD _0030_ sky130_fd_sc_hd__mux2_1
X_1366_ net83 _0220_ net48 VSS VSS VDD VDD regs\[25\]\[4\] sky130_fd_sc_hd__dfrtp_1
X_1297_ net110 _0151_ net75 VSS VSS VDD VDD regs\[16\]\[7\] sky130_fd_sc_hd__dfrtp_1
XFILLER_11_12 VSS VSS VDD VDD sky130_fd_sc_hd__decap_3
XFILLER_11_307 VSS VSS VDD VDD sky130_fd_sc_hd__decap_3
XFILLER_23_178 VSS VSS VDD VDD sky130_fd_sc_hd__decap_3
XFILLER_11_45 VSS VSS VDD VDD sky130_fd_sc_hd__decap_3
XFILLER_11_89 VSS VSS VDD VDD sky130_fd_sc_hd__decap_3
XFILLER_46_215 VSS VSS VDD VDD sky130_fd_sc_hd__fill_1
XFILLER_46_248 VSS VSS VDD VDD sky130_fd_sc_hd__decap_3
XFILLER_14_112 VSS VSS VDD VDD sky130_fd_sc_hd__decap_3
XFILLER_52_41 VSS VSS VDD VDD sky130_fd_sc_hd__decap_3
XFILLER_52_74 VSS VSS VDD VDD sky130_fd_sc_hd__decap_3
XFILLER_54_270 VSS VSS VDD VDD sky130_fd_sc_hd__decap_3
XFILLER_28_6 VSS VSS VDD VDD sky130_fd_sc_hd__decap_3
X_1220_ net92 _0074_ net57 VSS VSS VDD VDD regs\[7\]\[2\] sky130_fd_sc_hd__dfrtp_1
X_1151_ net106 _0005_ net71 VSS VSS VDD VDD regs\[31\]\[5\] sky130_fd_sc_hd__dfrtp_1
X_1082_ regs\[23\]\[7\] net155 _0268_ VSS VSS VDD VDD _0207_ sky130_fd_sc_hd__mux2_1
XFILLER_20_104 VSS VSS VDD VDD sky130_fd_sc_hd__decap_3
XFILLER_20_137 VSS VSS VDD VDD sky130_fd_sc_hd__decap_3
X_0935_ regs\[7\]\[4\] net164 _0561_ VSS VSS VDD VDD _0076_ sky130_fd_sc_hd__mux2_1
X_0866_ net147 net24 _0552_ _0553_ VSS VSS VDD VDD _0015_ sky130_fd_sc_hd__a22o_1
X_0797_ net132 regs\[16\]\[5\] net27 VSS VSS VDD VDD _0487_ sky130_fd_sc_hd__and3_1
XFILLER_28_248 VSS VSS VDD VDD sky130_fd_sc_hd__decap_3
X_1349_ net105 _0203_ net70 VSS VSS VDD VDD regs\[23\]\[3\] sky130_fd_sc_hd__dfrtp_1
XFILLER_11_104 VSS VSS VDD VDD sky130_fd_sc_hd__decap_3
XFILLER_11_126 VSS VSS VDD VDD sky130_fd_sc_hd__decap_3
XFILLER_51_284 VSS VSS VDD VDD sky130_fd_sc_hd__decap_3
XFILLER_22_77 VSS VSS VDD VDD sky130_fd_sc_hd__decap_3
XFILLER_3_314 VSS VSS VDD VDD sky130_fd_sc_hd__decap_3
XFILLER_7_108 VSS VSS VDD VDD sky130_fd_sc_hd__decap_3
XFILLER_47_30 VSS VSS VDD VDD sky130_fd_sc_hd__decap_3
Xfanout150 net16 VSS VSS VDD VDD net150 sky130_fd_sc_hd__clkbuf_2
Xfanout161 net13 VSS VSS VDD VDD net161 sky130_fd_sc_hd__buf_2
Xfanout172 net10 VSS VSS VDD VDD net172 sky130_fd_sc_hd__buf_2
XTAP_TAPCELL_ROW_6_163 VSS VDD sky130_fd_sc_hd__tapvpwrvgnd_1
XFILLER_19_237 VSS VSS VDD VDD sky130_fd_sc_hd__decap_3
XFILLER_27_292 VSS VSS VDD VDD sky130_fd_sc_hd__decap_3
XFILLER_34_207 VSS VSS VDD VDD sky130_fd_sc_hd__decap_3
XFILLER_47_63 VSS VSS VDD VDD sky130_fd_sc_hd__decap_3
XFILLER_47_96 VSS VSS VDD VDD sky130_fd_sc_hd__fill_1
XTAP_TAPCELL_ROW_29_298 VSS VDD sky130_fd_sc_hd__tapvpwrvgnd_1
XFILLER_42_262 VSS VSS VDD VDD sky130_fd_sc_hd__decap_3
XFILLER_42_295 VSS VSS VDD VDD sky130_fd_sc_hd__fill_2
XFILLER_8_24 VSS VSS VDD VDD sky130_fd_sc_hd__decap_3
XFILLER_8_35 VSS VSS VDD VDD sky130_fd_sc_hd__decap_3
X_0720_ net121 regs\[28\]\[3\] net36 _0316_ regs\[9\]\[3\] VSS VSS VDD VDD _0412_
+ sky130_fd_sc_hd__a32o_1
XFILLER_10_181 VSS VSS VDD VDD sky130_fd_sc_hd__fill_1
XFILLER_10_192 VSS VSS VDD VDD sky130_fd_sc_hd__decap_3
X_0651_ regs\[0\]\[0\] _0327_ net145 VSS VSS VDD VDD _0346_ sky130_fd_sc_hd__o21ba_1
X_0582_ regs\[31\]\[7\] net155 _0277_ VSS VSS VDD VDD _0007_ sky130_fd_sc_hd__mux2_1
XTAP_TAPCELL_ROW_12_198 VSS VDD sky130_fd_sc_hd__tapvpwrvgnd_1
XFILLER_26_3 VSS VSS VDD VDD sky130_fd_sc_hd__decap_3
X_1203_ net109 _0057_ net74 VSS VSS VDD VDD regs\[5\]\[1\] sky130_fd_sc_hd__dfrtp_1
X_1134_ regs\[29\]\[5\] net161 _0274_ VSS VSS VDD VDD _0253_ sky130_fd_sc_hd__mux2_1
XPHY_EDGE_ROW_25_Left_83 VSS VSS VDD VDD sky130_fd_sc_hd__decap_3
XFILLER_33_262 VSS VSS VDD VDD sky130_fd_sc_hd__decap_3
X_1065_ net136 net150 net32 VSS VSS VDD VDD _0267_ sky130_fd_sc_hd__and3_4
X_0918_ regs\[5\]\[5\] net162 _0559_ VSS VSS VDD VDD _0061_ sky130_fd_sc_hd__mux2_1
X_0849_ net121 regs\[14\]\[7\] net33 VSS VSS VDD VDD _0537_ sky130_fd_sc_hd__and3b_1
XFILLER_17_33 VSS VSS VDD VDD sky130_fd_sc_hd__decap_3
XFILLER_56_321 VSS VSS VDD VDD sky130_fd_sc_hd__decap_3
XTAP_TAPCELL_ROW_3_144 VSS VDD sky130_fd_sc_hd__tapvpwrvgnd_1
XFILLER_33_21 VSS VSS VDD VDD sky130_fd_sc_hd__decap_3
XFILLER_33_65 VSS VSS VDD VDD sky130_fd_sc_hd__fill_1
XTAP_TAPCELL_ROW_26_279 VSS VDD sky130_fd_sc_hd__tapvpwrvgnd_1
XFILLER_3_122 VSS VSS VDD VDD sky130_fd_sc_hd__fill_1
XFILLER_3_155 VSS VSS VDD VDD sky130_fd_sc_hd__decap_3
XFILLER_12_9 VSS VSS VDD VDD sky130_fd_sc_hd__decap_3
XFILLER_15_251 VSS VSS VDD VDD sky130_fd_sc_hd__decap_3
XTAP_TAPCELL_ROW_17_224 VSS VDD sky130_fd_sc_hd__tapvpwrvgnd_1
X_0703_ regs\[14\]\[2\] _0294_ _0307_ regs\[11\]\[2\] VSS VSS VDD VDD _0396_ sky130_fd_sc_hd__a22o_1
X_0634_ net121 regs\[25\]\[0\] _0315_ VSS VSS VDD VDD _0329_ sky130_fd_sc_hd__and3_1
X_1117_ regs\[27\]\[6\] net157 _0272_ VSS VSS VDD VDD _0238_ sky130_fd_sc_hd__mux2_1
XTAP_TAPCELL_ROW_0_125 VSS VDD sky130_fd_sc_hd__tapvpwrvgnd_1
XFILLER_0_91 VSS VSS VDD VDD sky130_fd_sc_hd__decap_3
XFILLER_21_276 VSS VSS VDD VDD sky130_fd_sc_hd__decap_3
X_1048_ regs\[20\]\[0\] net43 _0265_ VSS VSS VDD VDD _0176_ sky130_fd_sc_hd__mux2_1
XPHY_EDGE_ROW_3_Right_3 VSS VSS VDD VDD sky130_fd_sc_hd__decap_3
XFILLER_0_103 VSS VSS VDD VDD sky130_fd_sc_hd__decap_3
XFILLER_0_125 VSS VSS VDD VDD sky130_fd_sc_hd__decap_3
XFILLER_0_147 VSS VSS VDD VDD sky130_fd_sc_hd__decap_3
XFILLER_0_169 VSS VSS VDD VDD sky130_fd_sc_hd__decap_3
XFILLER_28_21 VSS VSS VDD VDD sky130_fd_sc_hd__decap_3
XFILLER_28_32 VSS VSS VDD VDD sky130_fd_sc_hd__fill_1
XFILLER_28_54 VSS VSS VDD VDD sky130_fd_sc_hd__fill_2
XFILLER_48_118 VSS VSS VDD VDD sky130_fd_sc_hd__decap_3
XFILLER_44_53 VSS VSS VDD VDD sky130_fd_sc_hd__decap_3
XFILLER_56_195 VSS VSS VDD VDD sky130_fd_sc_hd__fill_1
XTAP_TAPCELL_ROW_39_360 VSS VDD sky130_fd_sc_hd__tapvpwrvgnd_1
XFILLER_12_243 VSS VSS VDD VDD sky130_fd_sc_hd__decap_3
XFILLER_44_97 VSS VSS VDD VDD sky130_fd_sc_hd__decap_3
XFILLER_8_269 VSS VSS VDD VDD sky130_fd_sc_hd__decap_3
XFILLER_5_36 VSS VSS VDD VDD sky130_fd_sc_hd__decap_3
XFILLER_10_6 VSS VSS VDD VDD sky130_fd_sc_hd__decap_3
XFILLER_35_324 VSS VSS VDD VDD sky130_fd_sc_hd__decap_3
XFILLER_50_305 VSS VSS VDD VDD sky130_fd_sc_hd__decap_3
XTAP_TAPCELL_ROW_45_396 VSS VDD sky130_fd_sc_hd__tapvpwrvgnd_1
X_0617_ net143 net175 net141 net139 VSS VSS VDD VDD _0312_ sky130_fd_sc_hd__and4b_2
XFILLER_26_302 VSS VSS VDD VDD sky130_fd_sc_hd__fill_2
XFILLER_53_110 VSS VSS VDD VDD sky130_fd_sc_hd__fill_2
XFILLER_53_132 VSS VSS VDD VDD sky130_fd_sc_hd__decap_3
XFILLER_53_165 VSS VSS VDD VDD sky130_fd_sc_hd__decap_3
XTAP_TAPCELL_ROW_36_341 VSS VDD sky130_fd_sc_hd__tapvpwrvgnd_1
XFILLER_14_12 VSS VSS VDD VDD sky130_fd_sc_hd__decap_3
XFILLER_5_206 VSS VSS VDD VDD sky130_fd_sc_hd__fill_2
XPHY_EDGE_ROW_12_Left_70 VSS VSS VDD VDD sky130_fd_sc_hd__decap_3
XFILLER_30_77 VSS VSS VDD VDD sky130_fd_sc_hd__decap_3
XFILLER_39_42 VSS VSS VDD VDD sky130_fd_sc_hd__decap_3
XFILLER_55_30 VSS VSS VDD VDD sky130_fd_sc_hd__decap_3
XFILLER_44_165 VSS VSS VDD VDD sky130_fd_sc_hd__decap_3
XFILLER_55_63 VSS VSS VDD VDD sky130_fd_sc_hd__decap_3
XTAP_TAPCELL_ROW_42_377 VSS VDD sky130_fd_sc_hd__tapvpwrvgnd_1
X_1382_ net83 _0236_ net48 VSS VSS VDD VDD regs\[27\]\[4\] sky130_fd_sc_hd__dfrtp_1
XFILLER_23_305 VSS VSS VDD VDD sky130_fd_sc_hd__decap_3
XFILLER_35_110 VSS VSS VDD VDD sky130_fd_sc_hd__fill_2
XFILLER_35_121 VSS VSS VDD VDD sky130_fd_sc_hd__decap_3
XTAP_TAPCELL_ROW_33_322 VSS VDD sky130_fd_sc_hd__tapvpwrvgnd_1
XFILLER_26_110 VSS VSS VDD VDD sky130_fd_sc_hd__fill_1
XFILLER_14_305 VSS VSS VDD VDD sky130_fd_sc_hd__decap_3
XFILLER_25_33 VSS VSS VDD VDD sky130_fd_sc_hd__decap_3
XFILLER_25_66 VSS VSS VDD VDD sky130_fd_sc_hd__fill_1
XFILLER_25_99 VSS VSS VDD VDD sky130_fd_sc_hd__decap_3
XFILLER_41_102 VSS VSS VDD VDD sky130_fd_sc_hd__decap_3
XFILLER_41_124 VSS VSS VDD VDD sky130_fd_sc_hd__fill_1
XFILLER_41_157 VSS VSS VDD VDD sky130_fd_sc_hd__decap_3
XTAP_TAPCELL_ROW_56_458 VSS VDD sky130_fd_sc_hd__tapvpwrvgnd_1
XFILLER_41_21 VSS VSS VDD VDD sky130_fd_sc_hd__decap_3
XFILLER_41_76 VSS VSS VDD VDD sky130_fd_sc_hd__decap_3
XFILLER_1_231 VSS VSS VDD VDD sky130_fd_sc_hd__fill_2
XFILLER_1_253 VSS VSS VDD VDD sky130_fd_sc_hd__decap_3
XFILLER_2_15 VSS VSS VDD VDD sky130_fd_sc_hd__decap_3
XFILLER_2_59 VSS VSS VDD VDD sky130_fd_sc_hd__decap_3
XFILLER_17_143 VSS VSS VDD VDD sky130_fd_sc_hd__decap_3
XFILLER_57_290 VSS VSS VDD VDD sky130_fd_sc_hd__decap_3
XFILLER_32_179 VSS VSS VDD VDD sky130_fd_sc_hd__fill_2
X_0951_ regs\[9\]\[2\] net174 _0563_ VSS VSS VDD VDD _0090_ sky130_fd_sc_hd__mux2_1
X_0882_ net160 regs\[1\]\[5\] _0555_ VSS VSS VDD VDD _0029_ sky130_fd_sc_hd__mux2_1
XTAP_TAPCELL_ROW_30_303 VSS VDD sky130_fd_sc_hd__tapvpwrvgnd_1
XFILLER_56_3 VSS VSS VDD VDD sky130_fd_sc_hd__decap_3
XFILLER_55_205 VSS VSS VDD VDD sky130_fd_sc_hd__fill_2
XFILLER_55_216 VSS VSS VDD VDD sky130_fd_sc_hd__decap_3
X_1296_ net97 _0150_ net62 VSS VSS VDD VDD regs\[16\]\[6\] sky130_fd_sc_hd__dfrtp_1
X_1365_ net101 _0219_ net66 VSS VSS VDD VDD regs\[25\]\[3\] sky130_fd_sc_hd__dfrtp_1
XFILLER_11_24 VSS VSS VDD VDD sky130_fd_sc_hd__decap_3
XFILLER_11_79 VSS VSS VDD VDD sky130_fd_sc_hd__fill_2
XFILLER_36_21 VSS VSS VDD VDD sky130_fd_sc_hd__decap_3
XFILLER_36_32 VSS VSS VDD VDD sky130_fd_sc_hd__fill_1
XFILLER_46_227 VSS VSS VDD VDD sky130_fd_sc_hd__decap_3
XFILLER_14_135 VSS VSS VDD VDD sky130_fd_sc_hd__decap_3
XFILLER_14_157 VSS VSS VDD VDD sky130_fd_sc_hd__decap_3
XFILLER_52_53 VSS VSS VDD VDD sky130_fd_sc_hd__decap_3
XFILLER_54_282 VSS VSS VDD VDD sky130_fd_sc_hd__decap_3
XFILLER_54_293 VSS VSS VDD VDD sky130_fd_sc_hd__decap_3
X_1150_ net111 _0004_ net76 VSS VSS VDD VDD regs\[31\]\[4\] sky130_fd_sc_hd__dfrtp_1
XFILLER_45_271 VSS VSS VDD VDD sky130_fd_sc_hd__decap_3
X_1081_ regs\[23\]\[6\] net158 _0268_ VSS VSS VDD VDD _0206_ sky130_fd_sc_hd__mux2_1
XFILLER_20_116 VSS VSS VDD VDD sky130_fd_sc_hd__decap_3
X_0934_ regs\[7\]\[3\] net170 _0561_ VSS VSS VDD VDD _0075_ sky130_fd_sc_hd__mux2_1
X_0865_ regs\[0\]\[7\] _0327_ net147 VSS VSS VDD VDD _0553_ sky130_fd_sc_hd__o21ba_1
X_0796_ net132 regs\[17\]\[5\] _0278_ VSS VSS VDD VDD _0486_ sky130_fd_sc_hd__and3_1
XFILLER_28_205 VSS VSS VDD VDD sky130_fd_sc_hd__decap_3
XFILLER_36_260 VSS VSS VDD VDD sky130_fd_sc_hd__decap_3
XFILLER_3_91 VSS VSS VDD VDD sky130_fd_sc_hd__decap_3
XFILLER_43_219 VSS VSS VDD VDD sky130_fd_sc_hd__decap_3
X_1279_ net109 _0133_ net74 VSS VSS VDD VDD regs\[14\]\[5\] sky130_fd_sc_hd__dfrtp_1
X_1348_ net103 _0202_ net68 VSS VSS VDD VDD regs\[23\]\[2\] sky130_fd_sc_hd__dfrtp_1
XFILLER_11_138 VSS VSS VDD VDD sky130_fd_sc_hd__decap_3
XFILLER_22_12 VSS VSS VDD VDD sky130_fd_sc_hd__decap_3
XFILLER_51_296 VSS VSS VDD VDD sky130_fd_sc_hd__decap_3
XFILLER_47_42 VSS VSS VDD VDD sky130_fd_sc_hd__decap_3
Xfanout140 net4 VSS VSS VDD VDD net140 sky130_fd_sc_hd__dlymetal6s2s_1
Xfanout151 net153 VSS VSS VDD VDD net151 sky130_fd_sc_hd__buf_2
Xfanout162 net13 VSS VSS VDD VDD net162 sky130_fd_sc_hd__buf_2
Xfanout173 net10 VSS VSS VDD VDD net173 sky130_fd_sc_hd__buf_2
XFILLER_27_271 VSS VSS VDD VDD sky130_fd_sc_hd__decap_3
XFILLER_42_241 VSS VSS VDD VDD sky130_fd_sc_hd__decap_3
XTAP_TAPCELL_ROW_29_299 VSS VDD sky130_fd_sc_hd__tapvpwrvgnd_1
XFILLER_10_160 VSS VSS VDD VDD sky130_fd_sc_hd__decap_3
XFILLER_6_131 VSS VSS VDD VDD sky130_fd_sc_hd__decap_3
XFILLER_6_153 VSS VSS VDD VDD sky130_fd_sc_hd__decap_3
XFILLER_8_47 VSS VSS VDD VDD sky130_fd_sc_hd__fill_1
XTAP_TAPCELL_ROW_12_199 VSS VDD sky130_fd_sc_hd__tapvpwrvgnd_1
XFILLER_40_6 VSS VSS VDD VDD sky130_fd_sc_hd__decap_3
XFILLER_6_197 VSS VSS VDD VDD sky130_fd_sc_hd__decap_3
X_0650_ _0318_ _0331_ _0344_ VSS VSS VDD VDD _0345_ sky130_fd_sc_hd__or3_1
X_0581_ regs\[31\]\[6\] net158 _0277_ VSS VSS VDD VDD _0006_ sky130_fd_sc_hd__mux2_1
XFILLER_19_3 VSS VSS VDD VDD sky130_fd_sc_hd__decap_3
X_1202_ net110 _0056_ net75 VSS VSS VDD VDD regs\[5\]\[0\] sky130_fd_sc_hd__dfrtp_1
X_1133_ regs\[29\]\[4\] net164 _0274_ VSS VSS VDD VDD _0252_ sky130_fd_sc_hd__mux2_1
X_1064_ regs\[21\]\[7\] net155 _0266_ VSS VSS VDD VDD _0191_ sky130_fd_sc_hd__mux2_1
X_0917_ regs\[5\]\[4\] net166 _0559_ VSS VSS VDD VDD _0060_ sky130_fd_sc_hd__mux2_1
X_0848_ net121 regs\[29\]\[7\] net30 VSS VSS VDD VDD _0536_ sky130_fd_sc_hd__and3_1
X_0779_ net118 regs\[28\]\[5\] net36 _0468_ VSS VSS VDD VDD _0469_ sky130_fd_sc_hd__a31o_1
XFILLER_0_318 VSS VSS VDD VDD sky130_fd_sc_hd__decap_3
XFILLER_17_12 VSS VSS VDD VDD sky130_fd_sc_hd__decap_3
XFILLER_17_45 VSS VSS VDD VDD sky130_fd_sc_hd__decap_3
XFILLER_24_263 VSS VSS VDD VDD sky130_fd_sc_hd__decap_3
XFILLER_56_333 VSS VSS VDD VDD sky130_fd_sc_hd__decap_3
XTAP_TAPCELL_ROW_3_145 VSS VDD sky130_fd_sc_hd__tapvpwrvgnd_1
XFILLER_33_33 VSS VSS VDD VDD sky130_fd_sc_hd__decap_3
XFILLER_33_99 VSS VSS VDD VDD sky130_fd_sc_hd__decap_3
XFILLER_3_167 VSS VSS VDD VDD sky130_fd_sc_hd__fill_1
XFILLER_30_211 VSS VSS VDD VDD sky130_fd_sc_hd__fill_2
XFILLER_30_233 VSS VSS VDD VDD sky130_fd_sc_hd__decap_3
XTAP_TAPCELL_ROW_17_225 VSS VDD sky130_fd_sc_hd__tapvpwrvgnd_1
XFILLER_30_266 VSS VSS VDD VDD sky130_fd_sc_hd__decap_3
X_0702_ regs\[23\]\[2\] _0333_ _0326_ VSS VSS VDD VDD _0395_ sky130_fd_sc_hd__a21o_1
X_0633_ regs\[19\]\[0\] _0324_ _0326_ VSS VSS VDD VDD _0328_ sky130_fd_sc_hd__a21o_1
XFILLER_38_300 VSS VSS VDD VDD sky130_fd_sc_hd__decap_3
XFILLER_38_322 VSS VSS VDD VDD sky130_fd_sc_hd__fill_2
XFILLER_57_119 VSS VSS VDD VDD sky130_fd_sc_hd__decap_3
XFILLER_0_81 VSS VSS VDD VDD sky130_fd_sc_hd__decap_3
X_1116_ regs\[27\]\[5\] net161 _0272_ VSS VSS VDD VDD _0237_ sky130_fd_sc_hd__mux2_1
X_1047_ net134 net150 net28 VSS VSS VDD VDD _0265_ sky130_fd_sc_hd__and3_4
XTAP_TAPCELL_ROW_0_126 VSS VDD sky130_fd_sc_hd__tapvpwrvgnd_1
XFILLER_21_211 VSS VSS VDD VDD sky130_fd_sc_hd__decap_3
XFILLER_9_90 VSS VSS VDD VDD sky130_fd_sc_hd__decap_3
XFILLER_0_137 VSS VSS VDD VDD sky130_fd_sc_hd__decap_3
XFILLER_0_159 VSS VSS VDD VDD sky130_fd_sc_hd__decap_3
XFILLER_29_311 VSS VSS VDD VDD sky130_fd_sc_hd__decap_3
XFILLER_56_130 VSS VSS VDD VDD sky130_fd_sc_hd__decap_3
XFILLER_56_141 VSS VSS VDD VDD sky130_fd_sc_hd__fill_2
XFILLER_56_163 VSS VSS VDD VDD sky130_fd_sc_hd__decap_3
XTAP_TAPCELL_ROW_39_361 VSS VDD sky130_fd_sc_hd__tapvpwrvgnd_1
XFILLER_44_21 VSS VSS VDD VDD sky130_fd_sc_hd__decap_3
XFILLER_44_32 VSS VSS VDD VDD sky130_fd_sc_hd__decap_3
XFILLER_44_336 VSS VSS VDD VDD sky130_fd_sc_hd__fill_1
XTAP_TAPCELL_ROW_14_206 VSS VDD sky130_fd_sc_hd__tapvpwrvgnd_1
XFILLER_12_266 VSS VSS VDD VDD sky130_fd_sc_hd__decap_3
XFILLER_5_15 VSS VSS VDD VDD sky130_fd_sc_hd__decap_3
XFILLER_5_48 VSS VSS VDD VDD sky130_fd_sc_hd__decap_3
XPHY_EDGE_ROW_13_Right_13 VSS VSS VDD VDD sky130_fd_sc_hd__decap_3
XTAP_TAPCELL_ROW_45_397 VSS VDD sky130_fd_sc_hd__tapvpwrvgnd_1
XPHY_EDGE_ROW_22_Right_22 VSS VSS VDD VDD sky130_fd_sc_hd__decap_3
XFILLER_7_270 VSS VSS VDD VDD sky130_fd_sc_hd__decap_3
XFILLER_7_281 VSS VSS VDD VDD sky130_fd_sc_hd__decap_3
X_0616_ net126 regs\[30\]\[0\] net33 VSS VSS VDD VDD _0311_ sky130_fd_sc_hd__and3_1
XFILLER_38_141 VSS VSS VDD VDD sky130_fd_sc_hd__decap_3
XPHY_EDGE_ROW_31_Right_31 VSS VSS VDD VDD sky130_fd_sc_hd__decap_3
XFILLER_14_24 VSS VSS VDD VDD sky130_fd_sc_hd__decap_3
XFILLER_14_35 VSS VSS VDD VDD sky130_fd_sc_hd__decap_3
XFILLER_26_336 VSS VSS VDD VDD sky130_fd_sc_hd__decap_3
XFILLER_41_306 VSS VSS VDD VDD sky130_fd_sc_hd__decap_3
XFILLER_41_317 VSS VSS VDD VDD sky130_fd_sc_hd__decap_3
XFILLER_53_144 VSS VSS VDD VDD sky130_fd_sc_hd__fill_1
XTAP_TAPCELL_ROW_36_342 VSS VDD sky130_fd_sc_hd__tapvpwrvgnd_1
XFILLER_30_12 VSS VSS VDD VDD sky130_fd_sc_hd__decap_3
XFILLER_30_56 VSS VSS VDD VDD sky130_fd_sc_hd__decap_3
XPHY_EDGE_ROW_40_Right_40 VSS VSS VDD VDD sky130_fd_sc_hd__decap_3
XFILLER_39_21 VSS VSS VDD VDD sky130_fd_sc_hd__decap_3
XFILLER_39_54 VSS VSS VDD VDD sky130_fd_sc_hd__fill_2
XFILLER_44_100 VSS VSS VDD VDD sky130_fd_sc_hd__fill_2
XFILLER_44_111 VSS VSS VDD VDD sky130_fd_sc_hd__decap_3
XFILLER_44_133 VSS VSS VDD VDD sky130_fd_sc_hd__decap_3
XFILLER_44_144 VSS VSS VDD VDD sky130_fd_sc_hd__decap_3
XFILLER_55_42 VSS VSS VDD VDD sky130_fd_sc_hd__decap_3
XFILLER_55_75 VSS VSS VDD VDD sky130_fd_sc_hd__decap_3
XFILLER_44_177 VSS VSS VDD VDD sky130_fd_sc_hd__decap_3
XTAP_TAPCELL_ROW_42_378 VSS VDD sky130_fd_sc_hd__tapvpwrvgnd_1
XFILLER_4_262 VSS VSS VDD VDD sky130_fd_sc_hd__decap_3
X_1381_ net104 _0235_ net69 VSS VSS VDD VDD regs\[27\]\[3\] sky130_fd_sc_hd__dfrtp_1
XFILLER_50_136 VSS VSS VDD VDD sky130_fd_sc_hd__decap_3
XFILLER_50_147 VSS VSS VDD VDD sky130_fd_sc_hd__decap_3
XTAP_TAPCELL_ROW_33_323 VSS VDD sky130_fd_sc_hd__tapvpwrvgnd_1
XFILLER_25_12 VSS VSS VDD VDD sky130_fd_sc_hd__decap_3
XTAP_TAPCELL_ROW_56_459 VSS VDD sky130_fd_sc_hd__tapvpwrvgnd_1
XFILLER_25_45 VSS VSS VDD VDD sky130_fd_sc_hd__decap_3
XFILLER_26_177 VSS VSS VDD VDD sky130_fd_sc_hd__decap_3
XFILLER_41_136 VSS VSS VDD VDD sky130_fd_sc_hd__decap_3
XFILLER_41_169 VSS VSS VDD VDD sky130_fd_sc_hd__fill_2
XFILLER_41_33 VSS VSS VDD VDD sky130_fd_sc_hd__decap_3
XFILLER_41_55 VSS VSS VDD VDD sky130_fd_sc_hd__fill_1
XFILLER_41_66 VSS VSS VDD VDD sky130_fd_sc_hd__fill_1
XFILLER_1_221 VSS VSS VDD VDD sky130_fd_sc_hd__decap_3
XFILLER_1_276 VSS VSS VDD VDD sky130_fd_sc_hd__decap_3
XFILLER_2_27 VSS VSS VDD VDD sky130_fd_sc_hd__fill_1
XFILLER_2_38 VSS VSS VDD VDD sky130_fd_sc_hd__decap_3
XFILLER_49_258 VSS VSS VDD VDD sky130_fd_sc_hd__decap_3
XTAP_TAPCELL_ROW_47_404 VSS VDD sky130_fd_sc_hd__tapvpwrvgnd_1
XFILLER_17_122 VSS VSS VDD VDD sky130_fd_sc_hd__decap_3
XFILLER_32_136 VSS VSS VDD VDD sky130_fd_sc_hd__decap_3
X_0950_ regs\[9\]\[1\] net39 _0563_ VSS VSS VDD VDD _0089_ sky130_fd_sc_hd__mux2_1
X_0881_ net164 regs\[1\]\[4\] _0555_ VSS VSS VDD VDD _0028_ sky130_fd_sc_hd__mux2_1
XTAP_TAPCELL_ROW_30_304 VSS VDD sky130_fd_sc_hd__tapvpwrvgnd_1
XFILLER_49_3 VSS VSS VDD VDD sky130_fd_sc_hd__decap_3
XFILLER_48_280 VSS VSS VDD VDD sky130_fd_sc_hd__decap_3
X_1295_ net114 _0149_ net79 VSS VSS VDD VDD regs\[16\]\[5\] sky130_fd_sc_hd__dfrtp_1
X_1364_ net101 _0218_ net66 VSS VSS VDD VDD regs\[25\]\[2\] sky130_fd_sc_hd__dfrtp_1
XFILLER_23_169 VSS VSS VDD VDD sky130_fd_sc_hd__decap_3
XFILLER_11_36 VSS VSS VDD VDD sky130_fd_sc_hd__decap_3
XFILLER_2_9 VSS VSS VDD VDD sky130_fd_sc_hd__decap_3
XFILLER_46_206 VSS VSS VDD VDD sky130_fd_sc_hd__decap_3
XFILLER_46_239 VSS VSS VDD VDD sky130_fd_sc_hd__decap_3
XFILLER_14_147 VSS VSS VDD VDD sky130_fd_sc_hd__fill_2
XFILLER_52_10 VSS VSS VDD VDD sky130_fd_sc_hd__decap_3
XFILLER_52_32 VSS VSS VDD VDD sky130_fd_sc_hd__decap_3
XFILLER_52_65 VSS VSS VDD VDD sky130_fd_sc_hd__decap_3
XFILLER_35_9 VSS VSS VDD VDD sky130_fd_sc_hd__decap_3
XFILLER_37_206 VSS VSS VDD VDD sky130_fd_sc_hd__decap_3
XFILLER_37_239 VSS VSS VDD VDD sky130_fd_sc_hd__decap_3
X_1080_ regs\[23\]\[5\] net162 _0268_ VSS VSS VDD VDD _0205_ sky130_fd_sc_hd__mux2_1
XFILLER_20_128 VSS VSS VDD VDD sky130_fd_sc_hd__decap_3
X_0933_ regs\[7\]\[2\] net173 _0561_ VSS VSS VDD VDD _0074_ sky130_fd_sc_hd__mux2_1
X_0864_ _0530_ _0535_ _0551_ VSS VSS VDD VDD _0552_ sky130_fd_sc_hd__or3_1
X_0795_ net127 regs\[24\]\[5\] _0340_ VSS VSS VDD VDD _0485_ sky130_fd_sc_hd__and3_1
XFILLER_9_140 VSS VSS VDD VDD sky130_fd_sc_hd__decap_3
X_1347_ net103 _0201_ net68 VSS VSS VDD VDD regs\[23\]\[1\] sky130_fd_sc_hd__dfrtp_1
XFILLER_51_220 VSS VSS VDD VDD sky130_fd_sc_hd__decap_3
X_1278_ net100 _0132_ net65 VSS VSS VDD VDD regs\[14\]\[4\] sky130_fd_sc_hd__dfrtp_1
XFILLER_22_24 VSS VSS VDD VDD sky130_fd_sc_hd__decap_3
XFILLER_22_35 VSS VSS VDD VDD sky130_fd_sc_hd__decap_3
XFILLER_51_275 VSS VSS VDD VDD sky130_fd_sc_hd__decap_3
XFILLER_0_6 VSS VSS VDD VDD sky130_fd_sc_hd__decap_3
XFILLER_3_305 VSS VSS VDD VDD sky130_fd_sc_hd__decap_3
XFILLER_19_217 VSS VSS VDD VDD sky130_fd_sc_hd__decap_3
XFILLER_19_228 VSS VSS VDD VDD sky130_fd_sc_hd__decap_3
XFILLER_47_21 VSS VSS VDD VDD sky130_fd_sc_hd__decap_3
XFILLER_47_54 VSS VSS VDD VDD sky130_fd_sc_hd__fill_2
Xfanout130 net138 VSS VSS VDD VDD net130 sky130_fd_sc_hd__clkbuf_2
Xfanout141 net3 VSS VSS VDD VDD net141 sky130_fd_sc_hd__buf_2
Xfanout152 net153 VSS VSS VDD VDD net152 sky130_fd_sc_hd__buf_1
Xfanout163 net13 VSS VSS VDD VDD net163 sky130_fd_sc_hd__buf_1
Xfanout174 net10 VSS VSS VDD VDD net174 sky130_fd_sc_hd__buf_2
XFILLER_42_253 VSS VSS VDD VDD sky130_fd_sc_hd__decap_3
XFILLER_42_286 VSS VSS VDD VDD sky130_fd_sc_hd__decap_3
XFILLER_8_15 VSS VSS VDD VDD sky130_fd_sc_hd__decap_3
XFILLER_10_172 VSS VSS VDD VDD sky130_fd_sc_hd__decap_3
XFILLER_33_6 VSS VSS VDD VDD sky130_fd_sc_hd__decap_3
XFILLER_6_187 VSS VSS VDD VDD sky130_fd_sc_hd__decap_3
X_1201_ net104 _0055_ net69 VSS VSS VDD VDD regs\[4\]\[7\] sky130_fd_sc_hd__dfrtp_1
X_0580_ regs\[31\]\[5\] net162 _0277_ VSS VSS VDD VDD _0005_ sky130_fd_sc_hd__mux2_1
X_1132_ regs\[29\]\[3\] net169 _0274_ VSS VSS VDD VDD _0251_ sky130_fd_sc_hd__mux2_1
X_1063_ regs\[21\]\[6\] net158 _0266_ VSS VSS VDD VDD _0190_ sky130_fd_sc_hd__mux2_1
XFILLER_33_231 VSS VSS VDD VDD sky130_fd_sc_hd__decap_3
X_0916_ regs\[5\]\[3\] net171 _0559_ VSS VSS VDD VDD _0059_ sky130_fd_sc_hd__mux2_1
X_0847_ _0531_ _0532_ _0533_ _0534_ VSS VSS VDD VDD _0535_ sky130_fd_sc_hd__or4_1
X_0778_ net118 regs\[29\]\[5\] net30 VSS VSS VDD VDD _0468_ sky130_fd_sc_hd__and3_1
XFILLER_56_312 VSS VSS VDD VDD sky130_fd_sc_hd__decap_3
XFILLER_17_24 VSS VSS VDD VDD sky130_fd_sc_hd__decap_3
XFILLER_17_57 VSS VSS VDD VDD sky130_fd_sc_hd__decap_3
XFILLER_24_275 VSS VSS VDD VDD sky130_fd_sc_hd__decap_3
XFILLER_33_12 VSS VSS VDD VDD sky130_fd_sc_hd__decap_3
XFILLER_33_45 VSS VSS VDD VDD sky130_fd_sc_hd__decap_3
XFILLER_3_113 VSS VSS VDD VDD sky130_fd_sc_hd__decap_3
XFILLER_3_146 VSS VSS VDD VDD sky130_fd_sc_hd__decap_3
XTAP_TAPCELL_ROW_17_226 VSS VDD sky130_fd_sc_hd__tapvpwrvgnd_1
XFILLER_30_256 VSS VSS VDD VDD sky130_fd_sc_hd__decap_3
XFILLER_30_278 VSS VSS VDD VDD sky130_fd_sc_hd__fill_1
X_0701_ regs\[19\]\[2\] _0324_ _0332_ regs\[4\]\[2\] VSS VSS VDD VDD _0394_ sky130_fd_sc_hd__a22o_1
X_0632_ net123 net26 VSS VSS VDD VDD _0327_ sky130_fd_sc_hd__nand2b_2
XFILLER_31_3 VSS VSS VDD VDD sky130_fd_sc_hd__decap_3
XFILLER_57_109 VSS VSS VDD VDD sky130_fd_sc_hd__decap_3
XFILLER_0_60 VSS VSS VDD VDD sky130_fd_sc_hd__decap_3
XFILLER_53_304 VSS VSS VDD VDD sky130_fd_sc_hd__decap_3
XFILLER_53_337 VSS VSS VDD VDD sky130_fd_sc_hd__decap_3
X_1115_ regs\[27\]\[4\] net164 _0272_ VSS VSS VDD VDD _0236_ sky130_fd_sc_hd__mux2_1
X_1046_ regs\[19\]\[7\] net154 _0264_ VSS VSS VDD VDD _0175_ sky130_fd_sc_hd__mux2_1
XTAP_TAPCELL_ROW_0_127 VSS VDD sky130_fd_sc_hd__tapvpwrvgnd_1
XTAP_TAPCELL_ROW_0_116 VSS VDD sky130_fd_sc_hd__tapvpwrvgnd_1
XFILLER_21_223 VSS VSS VDD VDD sky130_fd_sc_hd__fill_1
XFILLER_21_245 VSS VSS VDD VDD sky130_fd_sc_hd__fill_1
XFILLER_0_116 VSS VSS VDD VDD sky130_fd_sc_hd__decap_3
XFILLER_28_12 VSS VSS VDD VDD sky130_fd_sc_hd__decap_3
XFILLER_48_109 VSS VSS VDD VDD sky130_fd_sc_hd__decap_3
XFILLER_56_197 VSS VSS VDD VDD sky130_fd_sc_hd__decap_3
XFILLER_44_44 VSS VSS VDD VDD sky130_fd_sc_hd__decap_3
XFILLER_44_77 VSS VSS VDD VDD sky130_fd_sc_hd__decap_3
XFILLER_44_88 VSS VSS VDD VDD sky130_fd_sc_hd__decap_3
XTAP_TAPCELL_ROW_14_207 VSS VDD sky130_fd_sc_hd__tapvpwrvgnd_1
XFILLER_12_289 VSS VSS VDD VDD sky130_fd_sc_hd__decap_3
XFILLER_5_27 VSS VSS VDD VDD sky130_fd_sc_hd__decap_3
XFILLER_47_186 VSS VSS VDD VDD sky130_fd_sc_hd__decap_3
XFILLER_7_293 VSS VSS VDD VDD sky130_fd_sc_hd__decap_3
X_0615_ net126 regs\[22\]\[0\] net32 VSS VSS VDD VDD _0310_ sky130_fd_sc_hd__and3_1
XFILLER_38_131 VSS VSS VDD VDD sky130_fd_sc_hd__fill_1
XFILLER_38_186 VSS VSS VDD VDD sky130_fd_sc_hd__decap_3
XFILLER_41_329 VSS VSS VDD VDD sky130_fd_sc_hd__fill_2
XFILLER_53_189 VSS VSS VDD VDD sky130_fd_sc_hd__fill_2
X_1029_ net136 net150 _0288_ VSS VSS VDD VDD _0572_ sky130_fd_sc_hd__and3_2
XTAP_TAPCELL_ROW_36_343 VSS VDD sky130_fd_sc_hd__tapvpwrvgnd_1
XPHY_EDGE_ROW_46_Left_104 VSS VSS VDD VDD sky130_fd_sc_hd__decap_3
XFILLER_30_24 VSS VSS VDD VDD sky130_fd_sc_hd__decap_3
XFILLER_30_68 VSS VSS VDD VDD sky130_fd_sc_hd__decap_3
XFILLER_39_33 VSS VSS VDD VDD sky130_fd_sc_hd__decap_3
XFILLER_39_66 VSS VSS VDD VDD sky130_fd_sc_hd__decap_3
XPHY_EDGE_ROW_55_Left_113 VSS VSS VDD VDD sky130_fd_sc_hd__decap_3
XFILLER_17_304 VSS VSS VDD VDD sky130_fd_sc_hd__decap_3
XFILLER_17_337 VSS VSS VDD VDD sky130_fd_sc_hd__fill_1
XFILLER_29_164 VSS VSS VDD VDD sky130_fd_sc_hd__decap_3
XFILLER_29_197 VSS VSS VDD VDD sky130_fd_sc_hd__fill_2
XFILLER_32_307 VSS VSS VDD VDD sky130_fd_sc_hd__fill_1
XFILLER_32_318 VSS VSS VDD VDD sky130_fd_sc_hd__decap_3
XFILLER_44_189 VSS VSS VDD VDD sky130_fd_sc_hd__decap_3
XFILLER_55_21 VSS VSS VDD VDD sky130_fd_sc_hd__decap_3
XFILLER_55_54 VSS VSS VDD VDD sky130_fd_sc_hd__fill_2
XFILLER_55_87 VSS VSS VDD VDD sky130_fd_sc_hd__decap_3
XFILLER_55_98 VSS VSS VDD VDD sky130_fd_sc_hd__decap_3
XTAP_TAPCELL_ROW_42_379 VSS VDD sky130_fd_sc_hd__tapvpwrvgnd_1
XFILLER_4_274 VSS VSS VDD VDD sky130_fd_sc_hd__decap_3
X_1380_ net114 _0234_ net79 VSS VSS VDD VDD regs\[27\]\[2\] sky130_fd_sc_hd__dfrtp_1
XFILLER_35_167 VSS VSS VDD VDD sky130_fd_sc_hd__fill_1
XFILLER_35_189 VSS VSS VDD VDD sky130_fd_sc_hd__decap_3
XTAP_TAPCELL_ROW_33_324 VSS VDD sky130_fd_sc_hd__tapvpwrvgnd_1
XFILLER_25_24 VSS VSS VDD VDD sky130_fd_sc_hd__decap_3
XFILLER_26_101 VSS VSS VDD VDD sky130_fd_sc_hd__decap_3
XFILLER_26_123 VSS VSS VDD VDD sky130_fd_sc_hd__decap_3
XFILLER_25_57 VSS VSS VDD VDD sky130_fd_sc_hd__decap_3
XFILLER_25_79 VSS VSS VDD VDD sky130_fd_sc_hd__decap_3
XFILLER_41_12 VSS VSS VDD VDD sky130_fd_sc_hd__decap_3
XFILLER_41_148 VSS VSS VDD VDD sky130_fd_sc_hd__fill_1
XFILLER_9_3 VSS VSS VDD VDD sky130_fd_sc_hd__decap_3
XFILLER_49_237 VSS VSS VDD VDD sky130_fd_sc_hd__fill_2
XFILLER_49_248 VSS VSS VDD VDD sky130_fd_sc_hd__decap_3
XFILLER_57_281 VSS VSS VDD VDD sky130_fd_sc_hd__decap_3
XTAP_TAPCELL_ROW_47_405 VSS VDD sky130_fd_sc_hd__tapvpwrvgnd_1
XFILLER_17_134 VSS VSS VDD VDD sky130_fd_sc_hd__decap_3
XFILLER_17_167 VSS VSS VDD VDD sky130_fd_sc_hd__fill_1
X_0880_ net168 regs\[1\]\[3\] _0555_ VSS VSS VDD VDD _0027_ sky130_fd_sc_hd__mux2_1
XTAP_TAPCELL_ROW_30_305 VSS VDD sky130_fd_sc_hd__tapvpwrvgnd_1
XFILLER_9_333 VSS VSS VDD VDD sky130_fd_sc_hd__decap_3
X_1363_ net82 _0217_ net47 VSS VSS VDD VDD regs\[25\]\[1\] sky130_fd_sc_hd__dfrtp_1
X_1294_ net97 _0148_ net62 VSS VSS VDD VDD regs\[16\]\[4\] sky130_fd_sc_hd__dfrtp_1
XFILLER_11_15 VSS VSS VDD VDD sky130_fd_sc_hd__decap_3
XFILLER_11_48 VSS VSS VDD VDD sky130_fd_sc_hd__decap_3
XFILLER_36_12 VSS VSS VDD VDD sky130_fd_sc_hd__decap_3
XFILLER_14_115 VSS VSS VDD VDD sky130_fd_sc_hd__fill_2
XFILLER_39_281 VSS VSS VDD VDD sky130_fd_sc_hd__fill_2
XFILLER_52_22 VSS VSS VDD VDD sky130_fd_sc_hd__decap_3
XFILLER_54_240 VSS VSS VDD VDD sky130_fd_sc_hd__decap_3
XFILLER_54_273 VSS VSS VDD VDD sky130_fd_sc_hd__decap_3
XFILLER_22_192 VSS VSS VDD VDD sky130_fd_sc_hd__decap_3
XFILLER_52_44 VSS VSS VDD VDD sky130_fd_sc_hd__decap_3
XFILLER_52_77 VSS VSS VDD VDD sky130_fd_sc_hd__decap_3
XFILLER_28_9 VSS VSS VDD VDD sky130_fd_sc_hd__decap_3
XFILLER_45_262 VSS VSS VDD VDD sky130_fd_sc_hd__decap_3
X_0932_ regs\[7\]\[1\] net39 _0561_ VSS VSS VDD VDD _0073_ sky130_fd_sc_hd__mux2_1
X_0863_ _0539_ _0542_ _0546_ _0550_ VSS VSS VDD VDD _0551_ sky130_fd_sc_hd__or4_1
X_0794_ regs\[5\]\[5\] _0291_ _0326_ _0482_ _0483_ VSS VSS VDD VDD _0484_ sky130_fd_sc_hd__a2111o_1
XFILLER_3_60 VSS VSS VDD VDD sky130_fd_sc_hd__decap_3
X_1346_ net104 _0200_ net69 VSS VSS VDD VDD regs\[23\]\[0\] sky130_fd_sc_hd__dfrtp_1
XFILLER_36_251 VSS VSS VDD VDD sky130_fd_sc_hd__fill_1
X_1277_ net95 _0131_ net60 VSS VSS VDD VDD regs\[14\]\[3\] sky130_fd_sc_hd__dfrtp_1
XFILLER_11_107 VSS VSS VDD VDD sky130_fd_sc_hd__decap_3
XFILLER_11_129 VSS VSS VDD VDD sky130_fd_sc_hd__decap_3
XFILLER_51_287 VSS VSS VDD VDD sky130_fd_sc_hd__decap_3
XFILLER_3_317 VSS VSS VDD VDD sky130_fd_sc_hd__decap_3
Xfanout120 net122 VSS VSS VDD VDD net120 sky130_fd_sc_hd__clkbuf_2
Xfanout131 net132 VSS VSS VDD VDD net131 sky130_fd_sc_hd__clkbuf_2
XFILLER_47_33 VSS VSS VDD VDD sky130_fd_sc_hd__decap_3
XFILLER_47_66 VSS VSS VDD VDD sky130_fd_sc_hd__fill_1
Xfanout142 net3 VSS VSS VDD VDD net142 sky130_fd_sc_hd__dlymetal6s2s_1
Xfanout153 net154 VSS VSS VDD VDD net153 sky130_fd_sc_hd__clkbuf_2
Xfanout164 net12 VSS VSS VDD VDD net164 sky130_fd_sc_hd__clkbuf_4
Xfanout175 net1 VSS VSS VDD VDD net175 sky130_fd_sc_hd__clkbuf_2
XFILLER_27_295 VSS VSS VDD VDD sky130_fd_sc_hd__decap_3
XFILLER_42_210 VSS VSS VDD VDD sky130_fd_sc_hd__decap_3
XFILLER_42_265 VSS VSS VDD VDD sky130_fd_sc_hd__fill_1
XFILLER_8_27 VSS VSS VDD VDD sky130_fd_sc_hd__fill_1
XFILLER_8_38 VSS VSS VDD VDD sky130_fd_sc_hd__decap_3
XFILLER_10_151 VSS VSS VDD VDD sky130_fd_sc_hd__decap_3
XFILLER_10_195 VSS VSS VDD VDD sky130_fd_sc_hd__fill_1
XFILLER_12_80 VSS VSS VDD VDD sky130_fd_sc_hd__decap_3
XFILLER_6_111 VSS VSS VDD VDD sky130_fd_sc_hd__fill_1
XFILLER_26_6 VSS VSS VDD VDD sky130_fd_sc_hd__decap_3
X_1200_ net114 _0054_ net79 VSS VSS VDD VDD regs\[4\]\[6\] sky130_fd_sc_hd__dfrtp_1
X_1131_ regs\[29\]\[2\] net174 _0274_ VSS VSS VDD VDD _0250_ sky130_fd_sc_hd__mux2_1
X_1062_ regs\[21\]\[5\] net163 _0266_ VSS VSS VDD VDD _0189_ sky130_fd_sc_hd__mux2_1
XTAP_TAPCELL_ROW_28_290 VSS VDD sky130_fd_sc_hd__tapvpwrvgnd_1
XFILLER_33_265 VSS VSS VDD VDD sky130_fd_sc_hd__decap_3
XFILLER_33_276 VSS VSS VDD VDD sky130_fd_sc_hd__decap_3
X_0915_ regs\[5\]\[2\] net174 _0559_ VSS VSS VDD VDD _0058_ sky130_fd_sc_hd__mux2_1
XFILLER_0_309 VSS VSS VDD VDD sky130_fd_sc_hd__decap_3
X_0846_ net120 regs\[27\]\[7\] net31 _0304_ regs\[7\]\[7\] VSS VSS VDD VDD _0534_
+ sky130_fd_sc_hd__a32o_1
X_0777_ net123 regs\[27\]\[5\] net31 _0301_ regs\[26\]\[5\] VSS VSS VDD VDD _0467_
+ sky130_fd_sc_hd__a32o_1
XTAP_TAPCELL_ROW_11_190 VSS VDD sky130_fd_sc_hd__tapvpwrvgnd_1
XFILLER_17_36 VSS VSS VDD VDD sky130_fd_sc_hd__decap_3
XFILLER_56_302 VSS VSS VDD VDD sky130_fd_sc_hd__decap_3
XFILLER_56_324 VSS VSS VDD VDD sky130_fd_sc_hd__decap_3
X_1329_ net105 _0183_ net70 VSS VSS VDD VDD regs\[20\]\[7\] sky130_fd_sc_hd__dfrtp_1
XFILLER_24_232 VSS VSS VDD VDD sky130_fd_sc_hd__decap_3
XFILLER_33_24 VSS VSS VDD VDD sky130_fd_sc_hd__decap_3
XFILLER_33_57 VSS VSS VDD VDD sky130_fd_sc_hd__fill_1
XFILLER_3_158 VSS VSS VDD VDD sky130_fd_sc_hd__decap_3
XFILLER_3_169 VSS VSS VDD VDD sky130_fd_sc_hd__decap_3
XFILLER_15_221 VSS VSS VDD VDD sky130_fd_sc_hd__decap_3
XTAP_TAPCELL_ROW_17_227 VSS VDD sky130_fd_sc_hd__tapvpwrvgnd_1
XFILLER_30_246 VSS VSS VDD VDD sky130_fd_sc_hd__decap_3
X_0700_ net132 regs\[22\]\[2\] net32 _0335_ regs\[12\]\[2\] VSS VSS VDD VDD _0393_
+ sky130_fd_sc_hd__a32o_1
X_0631_ net123 net26 VSS VSS VDD VDD _0326_ sky130_fd_sc_hd__and2b_4
XPHY_EDGE_ROW_29_Left_87 VSS VSS VDD VDD sky130_fd_sc_hd__decap_3
XFILLER_24_3 VSS VSS VDD VDD sky130_fd_sc_hd__decap_3
X_1114_ regs\[27\]\[3\] net169 _0272_ VSS VSS VDD VDD _0235_ sky130_fd_sc_hd__mux2_1
XTAP_TAPCELL_ROW_0_117 VSS VDD sky130_fd_sc_hd__tapvpwrvgnd_1
XFILLER_0_50 VSS VSS VDD VDD sky130_fd_sc_hd__decap_3
XFILLER_0_72 VSS VSS VDD VDD sky130_fd_sc_hd__decap_3
X_1045_ regs\[19\]\[6\] net157 _0264_ VSS VSS VDD VDD _0174_ sky130_fd_sc_hd__mux2_1
XFILLER_21_279 VSS VSS VDD VDD sky130_fd_sc_hd__fill_1
X_0829_ regs\[15\]\[6\] _0281_ _0294_ regs\[14\]\[6\] VSS VSS VDD VDD _0518_ sky130_fd_sc_hd__a22o_1
XFILLER_0_106 VSS VSS VDD VDD sky130_fd_sc_hd__decap_3
XFILLER_0_128 VSS VSS VDD VDD sky130_fd_sc_hd__decap_3
XFILLER_29_302 VSS VSS VDD VDD sky130_fd_sc_hd__decap_3
XFILLER_28_24 VSS VSS VDD VDD sky130_fd_sc_hd__decap_3
XFILLER_44_12 VSS VSS VDD VDD sky130_fd_sc_hd__decap_3
XFILLER_56_121 VSS VSS VDD VDD sky130_fd_sc_hd__decap_3
XFILLER_12_246 VSS VSS VDD VDD sky130_fd_sc_hd__decap_3
XFILLER_44_56 VSS VSS VDD VDD sky130_fd_sc_hd__fill_1
XFILLER_8_206 VSS VSS VDD VDD sky130_fd_sc_hd__decap_3
XTAP_TAPCELL_ROW_14_208 VSS VDD sky130_fd_sc_hd__tapvpwrvgnd_1
XFILLER_20_290 VSS VSS VDD VDD sky130_fd_sc_hd__fill_2
XFILLER_5_39 VSS VSS VDD VDD sky130_fd_sc_hd__decap_3
XFILLER_10_9 VSS VSS VDD VDD sky130_fd_sc_hd__decap_3
XFILLER_35_305 VSS VSS VDD VDD sky130_fd_sc_hd__decap_3
XFILLER_47_143 VSS VSS VDD VDD sky130_fd_sc_hd__decap_3
XFILLER_18_90 VSS VSS VDD VDD sky130_fd_sc_hd__fill_1
XFILLER_11_290 VSS VSS VDD VDD sky130_fd_sc_hd__decap_3
X_0614_ regs\[1\]\[0\] _0299_ _0302_ _0305_ _0308_ VSS VSS VDD VDD _0309_ sky130_fd_sc_hd__a2111o_1
XPHY_EDGE_ROW_7_Right_7 VSS VSS VDD VDD sky130_fd_sc_hd__decap_3
XFILLER_53_113 VSS VSS VDD VDD sky130_fd_sc_hd__decap_3
XFILLER_53_135 VSS VSS VDD VDD sky130_fd_sc_hd__decap_3
XFILLER_14_15 VSS VSS VDD VDD sky130_fd_sc_hd__decap_3
X_1028_ regs\[17\]\[7\] net153 _0571_ VSS VSS VDD VDD _0159_ sky130_fd_sc_hd__mux2_1
XFILLER_39_12 VSS VSS VDD VDD sky130_fd_sc_hd__decap_3
XFILLER_39_45 VSS VSS VDD VDD sky130_fd_sc_hd__decap_3
XFILLER_44_124 VSS VSS VDD VDD sky130_fd_sc_hd__decap_3
XFILLER_44_168 VSS VSS VDD VDD sky130_fd_sc_hd__decap_3
XFILLER_55_33 VSS VSS VDD VDD sky130_fd_sc_hd__decap_3
XFILLER_55_66 VSS VSS VDD VDD sky130_fd_sc_hd__decap_3
XFILLER_40_341 VSS VSS VDD VDD sky130_fd_sc_hd__decap_3
XFILLER_4_220 VSS VSS VDD VDD sky130_fd_sc_hd__decap_3
XFILLER_4_297 VSS VSS VDD VDD sky130_fd_sc_hd__fill_2
XFILLER_35_124 VSS VSS VDD VDD sky130_fd_sc_hd__fill_2
XFILLER_23_308 VSS VSS VDD VDD sky130_fd_sc_hd__decap_3
XFILLER_31_341 VSS VSS VDD VDD sky130_fd_sc_hd__decap_3
XTAP_TAPCELL_ROW_33_325 VSS VDD sky130_fd_sc_hd__tapvpwrvgnd_1
XFILLER_6_82 VSS VSS VDD VDD sky130_fd_sc_hd__fill_2
XFILLER_25_36 VSS VSS VDD VDD sky130_fd_sc_hd__decap_3
XFILLER_26_135 VSS VSS VDD VDD sky130_fd_sc_hd__decap_3
XFILLER_41_105 VSS VSS VDD VDD sky130_fd_sc_hd__decap_3
XPHY_EDGE_ROW_16_Left_74 VSS VSS VDD VDD sky130_fd_sc_hd__decap_3
XFILLER_22_341 VSS VSS VDD VDD sky130_fd_sc_hd__decap_3
XFILLER_34_190 VSS VSS VDD VDD sky130_fd_sc_hd__fill_2
XFILLER_41_24 VSS VSS VDD VDD sky130_fd_sc_hd__decap_3
XFILLER_41_79 VSS VSS VDD VDD sky130_fd_sc_hd__decap_3
XFILLER_49_205 VSS VSS VDD VDD sky130_fd_sc_hd__decap_3
XFILLER_17_146 VSS VSS VDD VDD sky130_fd_sc_hd__decap_3
XFILLER_2_18 VSS VSS VDD VDD sky130_fd_sc_hd__decap_3
XFILLER_2_29 VSS VSS VDD VDD sky130_fd_sc_hd__decap_3
XFILLER_49_216 VSS VSS VDD VDD sky130_fd_sc_hd__decap_3
XFILLER_57_271 VSS VSS VDD VDD sky130_fd_sc_hd__decap_3
XFILLER_57_293 VSS VSS VDD VDD sky130_fd_sc_hd__decap_3
XTAP_TAPCELL_ROW_47_406 VSS VDD sky130_fd_sc_hd__tapvpwrvgnd_1
XTAP_TAPCELL_ROW_30_306 VSS VDD sky130_fd_sc_hd__tapvpwrvgnd_1
XFILLER_56_6 VSS VSS VDD VDD sky130_fd_sc_hd__decap_3
X_1293_ net97 _0147_ net62 VSS VSS VDD VDD regs\[16\]\[3\] sky130_fd_sc_hd__dfrtp_1
X_1362_ net100 _0216_ net65 VSS VSS VDD VDD regs\[25\]\[0\] sky130_fd_sc_hd__dfrtp_1
XFILLER_48_271 VSS VSS VDD VDD sky130_fd_sc_hd__decap_3
XFILLER_55_219 VSS VSS VDD VDD sky130_fd_sc_hd__decap_3
XFILLER_11_27 VSS VSS VDD VDD sky130_fd_sc_hd__decap_3
XFILLER_36_24 VSS VSS VDD VDD sky130_fd_sc_hd__decap_3
XFILLER_10_300 VSS VSS VDD VDD sky130_fd_sc_hd__decap_3
XFILLER_14_138 VSS VSS VDD VDD sky130_fd_sc_hd__fill_2
XFILLER_36_57 VSS VSS VDD VDD sky130_fd_sc_hd__decap_3
XFILLER_52_56 VSS VSS VDD VDD sky130_fd_sc_hd__decap_3
XFILLER_54_285 VSS VSS VDD VDD sky130_fd_sc_hd__decap_3
XPHY_EDGE_ROW_1_Left_59 VSS VSS VDD VDD sky130_fd_sc_hd__decap_3
XFILLER_45_274 VSS VSS VDD VDD sky130_fd_sc_hd__decap_3
XFILLER_20_119 VSS VSS VDD VDD sky130_fd_sc_hd__decap_3
X_0931_ regs\[7\]\[0\] net46 _0561_ VSS VSS VDD VDD _0072_ sky130_fd_sc_hd__mux2_1
X_0862_ regs\[3\]\[7\] _0284_ _0547_ _0548_ _0549_ VSS VSS VDD VDD _0550_ sky130_fd_sc_hd__a2111o_1
XFILLER_9_164 VSS VSS VDD VDD sky130_fd_sc_hd__decap_3
X_0793_ net134 regs\[30\]\[5\] net33 VSS VSS VDD VDD _0483_ sky130_fd_sc_hd__and3_1
XFILLER_3_94 VSS VSS VDD VDD sky130_fd_sc_hd__fill_1
X_1276_ net96 _0130_ net61 VSS VSS VDD VDD regs\[14\]\[2\] sky130_fd_sc_hd__dfrtp_1
X_1345_ net110 _0199_ net75 VSS VSS VDD VDD regs\[22\]\[7\] sky130_fd_sc_hd__dfrtp_1
XFILLER_36_230 VSS VSS VDD VDD sky130_fd_sc_hd__fill_1
XFILLER_36_263 VSS VSS VDD VDD sky130_fd_sc_hd__decap_3
XFILLER_22_15 VSS VSS VDD VDD sky130_fd_sc_hd__decap_3
XFILLER_22_59 VSS VSS VDD VDD sky130_fd_sc_hd__decap_3
XFILLER_51_299 VSS VSS VDD VDD sky130_fd_sc_hd__decap_3
XFILLER_47_12 VSS VSS VDD VDD sky130_fd_sc_hd__decap_3
Xfanout110 net116 VSS VSS VDD VDD net110 sky130_fd_sc_hd__clkbuf_2
Xfanout121 net122 VSS VSS VDD VDD net121 sky130_fd_sc_hd__clkbuf_2
Xfanout132 net137 VSS VSS VDD VDD net132 sky130_fd_sc_hd__buf_2
Xfanout143 net2 VSS VSS VDD VDD net143 sky130_fd_sc_hd__buf_2
Xfanout154 net155 VSS VSS VDD VDD net154 sky130_fd_sc_hd__buf_2
Xfanout165 net12 VSS VSS VDD VDD net165 sky130_fd_sc_hd__dlymetal6s2s_1
XFILLER_27_252 VSS VSS VDD VDD sky130_fd_sc_hd__decap_3
XFILLER_27_274 VSS VSS VDD VDD sky130_fd_sc_hd__decap_3
XFILLER_47_45 VSS VSS VDD VDD sky130_fd_sc_hd__decap_3
Xfanout176 net1 VSS VSS VDD VDD net176 sky130_fd_sc_hd__dlymetal6s2s_1
XFILLER_42_244 VSS VSS VDD VDD sky130_fd_sc_hd__decap_3
XFILLER_10_163 VSS VSS VDD VDD sky130_fd_sc_hd__decap_3
XFILLER_12_70 VSS VSS VDD VDD sky130_fd_sc_hd__fill_1
XFILLER_40_9 VSS VSS VDD VDD sky130_fd_sc_hd__decap_3
XFILLER_6_134 VSS VSS VDD VDD sky130_fd_sc_hd__decap_3
XFILLER_6_156 VSS VSS VDD VDD sky130_fd_sc_hd__decap_3
XFILLER_19_6 VSS VSS VDD VDD sky130_fd_sc_hd__decap_3
X_1130_ regs\[29\]\[1\] net39 _0274_ VSS VSS VDD VDD _0249_ sky130_fd_sc_hd__mux2_1
XFILLER_33_222 VSS VSS VDD VDD sky130_fd_sc_hd__fill_2
X_1061_ regs\[21\]\[4\] net166 _0266_ VSS VSS VDD VDD _0188_ sky130_fd_sc_hd__mux2_1
XTAP_TAPCELL_ROW_28_291 VSS VDD sky130_fd_sc_hd__tapvpwrvgnd_1
X_0914_ regs\[5\]\[1\] net40 _0559_ VSS VSS VDD VDD _0057_ sky130_fd_sc_hd__mux2_1
X_0845_ net131 regs\[22\]\[7\] net32 _0338_ regs\[10\]\[7\] VSS VSS VDD VDD _0533_
+ sky130_fd_sc_hd__a32o_1
XTAP_TAPCELL_ROW_11_191 VSS VDD sky130_fd_sc_hd__tapvpwrvgnd_1
X_0776_ regs\[1\]\[5\] _0299_ _0304_ regs\[7\]\[5\] VSS VSS VDD VDD _0466_ sky130_fd_sc_hd__a22o_1
XFILLER_17_15 VSS VSS VDD VDD sky130_fd_sc_hd__decap_3
XFILLER_17_48 VSS VSS VDD VDD sky130_fd_sc_hd__decap_3
XFILLER_56_336 VSS VSS VDD VDD sky130_fd_sc_hd__decap_3
X_1259_ net109 _0113_ net74 VSS VSS VDD VDD regs\[12\]\[1\] sky130_fd_sc_hd__dfrtp_1
X_1328_ net96 _0182_ net61 VSS VSS VDD VDD regs\[20\]\[6\] sky130_fd_sc_hd__dfrtp_1
XFILLER_24_266 VSS VSS VDD VDD sky130_fd_sc_hd__decap_3
XFILLER_33_36 VSS VSS VDD VDD sky130_fd_sc_hd__decap_3
XFILLER_3_104 VSS VSS VDD VDD sky130_fd_sc_hd__decap_3
XTAP_TAPCELL_ROW_17_228 VSS VDD sky130_fd_sc_hd__tapvpwrvgnd_1
XPHY_EDGE_ROW_4_Left_62 VSS VSS VDD VDD sky130_fd_sc_hd__decap_3
XFILLER_30_236 VSS VSS VDD VDD sky130_fd_sc_hd__fill_1
XFILLER_30_269 VSS VSS VDD VDD sky130_fd_sc_hd__decap_3
XTAP_TAPCELL_ROW_25_272 VSS VDD sky130_fd_sc_hd__tapvpwrvgnd_1
X_0630_ net143 net175 net141 net139 VSS VSS VDD VDD _0325_ sky130_fd_sc_hd__nor4_1
XFILLER_17_3 VSS VSS VDD VDD sky130_fd_sc_hd__decap_3
XFILLER_38_303 VSS VSS VDD VDD sky130_fd_sc_hd__decap_3
XFILLER_53_328 VSS VSS VDD VDD sky130_fd_sc_hd__decap_3
X_1113_ regs\[27\]\[2\] net10 _0272_ VSS VSS VDD VDD _0234_ sky130_fd_sc_hd__mux2_1
X_1044_ regs\[19\]\[5\] net160 _0264_ VSS VSS VDD VDD _0173_ sky130_fd_sc_hd__mux2_1
XTAP_TAPCELL_ROW_0_118 VSS VDD sky130_fd_sc_hd__tapvpwrvgnd_1
XFILLER_21_214 VSS VSS VDD VDD sky130_fd_sc_hd__decap_3
XFILLER_9_60 VSS VSS VDD VDD sky130_fd_sc_hd__decap_3
X_0828_ regs\[5\]\[6\] _0291_ _0297_ regs\[6\]\[6\] VSS VSS VDD VDD _0517_ sky130_fd_sc_hd__a22o_1
X_0759_ net131 regs\[18\]\[4\] net35 VSS VSS VDD VDD _0450_ sky130_fd_sc_hd__and3_1
XFILLER_9_93 VSS VSS VDD VDD sky130_fd_sc_hd__fill_1
XFILLER_29_314 VSS VSS VDD VDD sky130_fd_sc_hd__fill_2
XFILLER_56_100 VSS VSS VDD VDD sky130_fd_sc_hd__decap_3
XFILLER_44_24 VSS VSS VDD VDD sky130_fd_sc_hd__decap_3
XFILLER_44_35 VSS VSS VDD VDD sky130_fd_sc_hd__decap_3
XFILLER_56_133 VSS VSS VDD VDD sky130_fd_sc_hd__decap_3
XTAP_TAPCELL_ROW_14_209 VSS VDD sky130_fd_sc_hd__tapvpwrvgnd_1
XPHY_EDGE_ROW_30_Left_88 VSS VSS VDD VDD sky130_fd_sc_hd__decap_3
XFILLER_5_18 VSS VSS VDD VDD sky130_fd_sc_hd__decap_3
XFILLER_47_122 VSS VSS VDD VDD sky130_fd_sc_hd__fill_1
XFILLER_47_166 VSS VSS VDD VDD sky130_fd_sc_hd__fill_2
XFILLER_7_273 VSS VSS VDD VDD sky130_fd_sc_hd__decap_3
XFILLER_7_284 VSS VSS VDD VDD sky130_fd_sc_hd__decap_3
X_0613_ net119 regs\[11\]\[0\] net31 VSS VSS VDD VDD _0308_ sky130_fd_sc_hd__and3b_1
XFILLER_38_100 VSS VSS VDD VDD sky130_fd_sc_hd__decap_3
XFILLER_26_339 VSS VSS VDD VDD sky130_fd_sc_hd__decap_3
XFILLER_38_144 VSS VSS VDD VDD sky130_fd_sc_hd__fill_2
XFILLER_41_309 VSS VSS VDD VDD sky130_fd_sc_hd__fill_1
X_1027_ regs\[17\]\[6\] net158 _0571_ VSS VSS VDD VDD _0158_ sky130_fd_sc_hd__mux2_1
XFILLER_14_27 VSS VSS VDD VDD sky130_fd_sc_hd__fill_1
XFILLER_14_38 VSS VSS VDD VDD sky130_fd_sc_hd__decap_3
XFILLER_30_15 VSS VSS VDD VDD sky130_fd_sc_hd__decap_3
XFILLER_30_59 VSS VSS VDD VDD sky130_fd_sc_hd__fill_1
XFILLER_39_24 VSS VSS VDD VDD sky130_fd_sc_hd__decap_3
XFILLER_29_122 VSS VSS VDD VDD sky130_fd_sc_hd__fill_2
XFILLER_29_133 VSS VSS VDD VDD sky130_fd_sc_hd__decap_3
XFILLER_55_12 VSS VSS VDD VDD sky130_fd_sc_hd__decap_3
XFILLER_44_114 VSS VSS VDD VDD sky130_fd_sc_hd__fill_1
XFILLER_44_136 VSS VSS VDD VDD sky130_fd_sc_hd__decap_3
XFILLER_55_45 VSS VSS VDD VDD sky130_fd_sc_hd__decap_3
XFILLER_55_78 VSS VSS VDD VDD sky130_fd_sc_hd__decap_3
XFILLER_20_92 VSS VSS VDD VDD sky130_fd_sc_hd__decap_3
XFILLER_4_265 VSS VSS VDD VDD sky130_fd_sc_hd__decap_3
XFILLER_4_287 VSS VSS VDD VDD sky130_fd_sc_hd__fill_1
XFILLER_29_90 VSS VSS VDD VDD sky130_fd_sc_hd__fill_2
XFILLER_50_139 VSS VSS VDD VDD sky130_fd_sc_hd__fill_1
XTAP_TAPCELL_ROW_41_370 VSS VDD sky130_fd_sc_hd__tapvpwrvgnd_1
XFILLER_6_50 VSS VSS VDD VDD sky130_fd_sc_hd__decap_3
XFILLER_6_72 VSS VSS VDD VDD sky130_fd_sc_hd__fill_1
XFILLER_6_94 VSS VSS VDD VDD sky130_fd_sc_hd__decap_3
XFILLER_14_309 VSS VSS VDD VDD sky130_fd_sc_hd__decap_3
XFILLER_25_15 VSS VSS VDD VDD sky130_fd_sc_hd__decap_3
XFILLER_25_48 VSS VSS VDD VDD sky130_fd_sc_hd__decap_3
XFILLER_26_147 VSS VSS VDD VDD sky130_fd_sc_hd__fill_1
XFILLER_41_139 VSS VSS VDD VDD sky130_fd_sc_hd__decap_3
XFILLER_41_36 VSS VSS VDD VDD sky130_fd_sc_hd__decap_3
XFILLER_1_279 VSS VSS VDD VDD sky130_fd_sc_hd__fill_1
XFILLER_17_103 VSS VSS VDD VDD sky130_fd_sc_hd__decap_3
XFILLER_17_125 VSS VSS VDD VDD sky130_fd_sc_hd__decap_3
XFILLER_17_158 VSS VSS VDD VDD sky130_fd_sc_hd__decap_3
XFILLER_17_169 VSS VSS VDD VDD sky130_fd_sc_hd__decap_3
XTAP_TAPCELL_ROW_47_407 VSS VDD sky130_fd_sc_hd__tapvpwrvgnd_1
XFILLER_13_320 VSS VSS VDD VDD sky130_fd_sc_hd__decap_3
XFILLER_25_191 VSS VSS VDD VDD sky130_fd_sc_hd__decap_3
XFILLER_32_139 VSS VSS VDD VDD sky130_fd_sc_hd__fill_1
XFILLER_40_194 VSS VSS VDD VDD sky130_fd_sc_hd__fill_2
XTAP_TAPCELL_ROW_30_307 VSS VDD sky130_fd_sc_hd__tapvpwrvgnd_1
XFILLER_49_6 VSS VSS VDD VDD sky130_fd_sc_hd__decap_3
XPHY_EDGE_ROW_33_Left_91 VSS VSS VDD VDD sky130_fd_sc_hd__decap_3
XFILLER_0_290 VSS VSS VDD VDD sky130_fd_sc_hd__decap_3
X_1292_ net95 _0146_ net60 VSS VSS VDD VDD regs\[16\]\[2\] sky130_fd_sc_hd__dfrtp_1
X_1361_ net86 _0215_ net51 VSS VSS VDD VDD regs\[24\]\[7\] sky130_fd_sc_hd__dfrtp_1
XFILLER_48_283 VSS VSS VDD VDD sky130_fd_sc_hd__decap_3
XFILLER_11_39 VSS VSS VDD VDD sky130_fd_sc_hd__decap_3
XFILLER_31_172 VSS VSS VDD VDD sky130_fd_sc_hd__decap_3
XFILLER_39_272 VSS VSS VDD VDD sky130_fd_sc_hd__decap_3
XFILLER_46_209 VSS VSS VDD VDD sky130_fd_sc_hd__decap_3
XFILLER_54_231 VSS VSS VDD VDD sky130_fd_sc_hd__decap_3
XFILLER_54_253 VSS VSS VDD VDD sky130_fd_sc_hd__decap_3
XFILLER_10_323 VSS VSS VDD VDD sky130_fd_sc_hd__fill_1
XFILLER_52_13 VSS VSS VDD VDD sky130_fd_sc_hd__decap_3
XFILLER_52_35 VSS VSS VDD VDD sky130_fd_sc_hd__decap_3
XFILLER_52_68 VSS VSS VDD VDD sky130_fd_sc_hd__decap_3
XFILLER_6_305 VSS VSS VDD VDD sky130_fd_sc_hd__decap_3
XFILLER_37_209 VSS VSS VDD VDD sky130_fd_sc_hd__decap_3
XTAP_TAPCELL_ROW_9_176 VSS VDD sky130_fd_sc_hd__tapvpwrvgnd_1
XFILLER_26_91 VSS VSS VDD VDD sky130_fd_sc_hd__fill_1
XFILLER_13_172 VSS VSS VDD VDD sky130_fd_sc_hd__decap_3
X_0930_ net147 _0304_ VSS VSS VDD VDD _0561_ sky130_fd_sc_hd__and2_2
X_0861_ net120 regs\[26\]\[7\] _0300_ VSS VSS VDD VDD _0549_ sky130_fd_sc_hd__and3_1
X_0792_ net134 regs\[21\]\[5\] _0290_ VSS VSS VDD VDD _0482_ sky130_fd_sc_hd__and3_1
XFILLER_9_143 VSS VSS VDD VDD sky130_fd_sc_hd__decap_3
XFILLER_47_3 VSS VSS VDD VDD sky130_fd_sc_hd__decap_3
XFILLER_36_253 VSS VSS VDD VDD sky130_fd_sc_hd__fill_2
XFILLER_3_51 VSS VSS VDD VDD sky130_fd_sc_hd__decap_3
X_1275_ net109 _0129_ net74 VSS VSS VDD VDD regs\[14\]\[1\] sky130_fd_sc_hd__dfrtp_1
X_1344_ net114 _0198_ net79 VSS VSS VDD VDD regs\[22\]\[6\] sky130_fd_sc_hd__dfrtp_1
Xwire35 _0288_ VSS VSS VDD VDD net35 sky130_fd_sc_hd__clkbuf_2
XFILLER_51_223 VSS VSS VDD VDD sky130_fd_sc_hd__fill_1
XFILLER_51_234 VSS VSS VDD VDD sky130_fd_sc_hd__fill_1
XFILLER_51_278 VSS VSS VDD VDD sky130_fd_sc_hd__fill_2
XFILLER_22_27 VSS VSS VDD VDD sky130_fd_sc_hd__fill_1
XFILLER_22_38 VSS VSS VDD VDD sky130_fd_sc_hd__fill_1
XFILLER_3_308 VSS VSS VDD VDD sky130_fd_sc_hd__decap_3
XFILLER_0_9 VSS VSS VDD VDD sky130_fd_sc_hd__decap_3
XFILLER_47_24 VSS VSS VDD VDD sky130_fd_sc_hd__decap_3
Xfanout100 net107 VSS VSS VDD VDD net100 sky130_fd_sc_hd__clkbuf_2
Xfanout111 net116 VSS VSS VDD VDD net111 sky130_fd_sc_hd__clkbuf_2
Xfanout122 net138 VSS VSS VDD VDD net122 sky130_fd_sc_hd__clkbuf_2
Xfanout133 net137 VSS VSS VDD VDD net133 sky130_fd_sc_hd__clkbuf_2
Xfanout144 net2 VSS VSS VDD VDD net144 sky130_fd_sc_hd__buf_1
Xfanout155 net15 VSS VSS VDD VDD net155 sky130_fd_sc_hd__buf_2
Xfanout166 net167 VSS VSS VDD VDD net166 sky130_fd_sc_hd__buf_2
XFILLER_42_201 VSS VSS VDD VDD sky130_fd_sc_hd__decap_3
XFILLER_47_57 VSS VSS VDD VDD sky130_fd_sc_hd__decap_3
XPHY_EDGE_ROW_29_Right_29 VSS VSS VDD VDD sky130_fd_sc_hd__decap_3
XFILLER_10_131 VSS VSS VDD VDD sky130_fd_sc_hd__decap_3
XFILLER_10_175 VSS VSS VDD VDD sky130_fd_sc_hd__decap_3
XFILLER_10_186 VSS VSS VDD VDD sky130_fd_sc_hd__decap_3
XFILLER_42_256 VSS VSS VDD VDD sky130_fd_sc_hd__decap_3
XFILLER_42_289 VSS VSS VDD VDD sky130_fd_sc_hd__decap_3
XFILLER_8_18 VSS VSS VDD VDD sky130_fd_sc_hd__decap_3
XFILLER_8_29 VSS VSS VDD VDD sky130_fd_sc_hd__decap_3
XPHY_EDGE_ROW_38_Right_38 VSS VSS VDD VDD sky130_fd_sc_hd__decap_3
XFILLER_10_197 VSS VSS VDD VDD sky130_fd_sc_hd__decap_3
XFILLER_33_9 VSS VSS VDD VDD sky130_fd_sc_hd__decap_3
X_1060_ regs\[21\]\[3\] net171 _0266_ VSS VSS VDD VDD _0187_ sky130_fd_sc_hd__mux2_1
XPHY_EDGE_ROW_47_Right_47 VSS VSS VDD VDD sky130_fd_sc_hd__decap_3
XFILLER_33_234 VSS VSS VDD VDD sky130_fd_sc_hd__decap_3
XTAP_TAPCELL_ROW_28_292 VSS VDD sky130_fd_sc_hd__tapvpwrvgnd_1
XPHY_EDGE_ROW_56_Right_56 VSS VSS VDD VDD sky130_fd_sc_hd__decap_3
X_0913_ regs\[5\]\[0\] net45 _0559_ VSS VSS VDD VDD _0056_ sky130_fd_sc_hd__mux2_1
X_0844_ regs\[17\]\[7\] _0279_ _0333_ regs\[23\]\[7\] VSS VSS VDD VDD _0532_ sky130_fd_sc_hd__a22o_1
X_0775_ regs\[3\]\[5\] _0284_ _0297_ regs\[6\]\[5\] VSS VSS VDD VDD _0465_ sky130_fd_sc_hd__a22o_1
XTAP_TAPCELL_ROW_11_192 VSS VDD sky130_fd_sc_hd__tapvpwrvgnd_1
XFILLER_17_27 VSS VSS VDD VDD sky130_fd_sc_hd__decap_3
XFILLER_56_315 VSS VSS VDD VDD sky130_fd_sc_hd__decap_3
X_1258_ net89 _0112_ net54 VSS VSS VDD VDD regs\[12\]\[0\] sky130_fd_sc_hd__dfrtp_1
X_1327_ net112 _0181_ net77 VSS VSS VDD VDD regs\[20\]\[5\] sky130_fd_sc_hd__dfrtp_1
X_1189_ net104 _0043_ net69 VSS VSS VDD VDD regs\[3\]\[3\] sky130_fd_sc_hd__dfrtp_1
XFILLER_24_278 VSS VSS VDD VDD sky130_fd_sc_hd__fill_2
XFILLER_33_15 VSS VSS VDD VDD sky130_fd_sc_hd__decap_3
XFILLER_33_48 VSS VSS VDD VDD sky130_fd_sc_hd__fill_1
XFILLER_3_116 VSS VSS VDD VDD sky130_fd_sc_hd__decap_3
XFILLER_3_149 VSS VSS VDD VDD sky130_fd_sc_hd__decap_3
XTAP_TAPCELL_ROW_25_273 VSS VDD sky130_fd_sc_hd__tapvpwrvgnd_1
XTAP_TAPCELL_ROW_17_229 VSS VDD sky130_fd_sc_hd__tapvpwrvgnd_1
XFILLER_30_259 VSS VSS VDD VDD sky130_fd_sc_hd__fill_1
XFILLER_31_6 VSS VSS VDD VDD sky130_fd_sc_hd__decap_3
XFILLER_0_41 VSS VSS VDD VDD sky130_fd_sc_hd__decap_3
XFILLER_0_63 VSS VSS VDD VDD sky130_fd_sc_hd__decap_3
XFILLER_0_85 VSS VSS VDD VDD sky130_fd_sc_hd__decap_3
XFILLER_53_307 VSS VSS VDD VDD sky130_fd_sc_hd__fill_1
X_1112_ regs\[27\]\[1\] net41 _0272_ VSS VSS VDD VDD _0233_ sky130_fd_sc_hd__mux2_1
X_1043_ regs\[19\]\[4\] net165 _0264_ VSS VSS VDD VDD _0172_ sky130_fd_sc_hd__mux2_1
XTAP_TAPCELL_ROW_0_119 VSS VDD sky130_fd_sc_hd__tapvpwrvgnd_1
X_0827_ _0511_ _0512_ _0514_ _0515_ VSS VSS VDD VDD _0516_ sky130_fd_sc_hd__or4_1
X_0758_ _0438_ _0442_ _0444_ _0448_ VSS VSS VDD VDD _0449_ sky130_fd_sc_hd__or4_1
XFILLER_0_119 VSS VSS VDD VDD sky130_fd_sc_hd__decap_3
XFILLER_28_15 VSS VSS VDD VDD sky130_fd_sc_hd__decap_3
XFILLER_29_337 VSS VSS VDD VDD sky130_fd_sc_hd__fill_1
XFILLER_56_112 VSS VSS VDD VDD sky130_fd_sc_hd__decap_3
X_0689_ net119 regs\[29\]\[2\] net30 VSS VSS VDD VDD _0382_ sky130_fd_sc_hd__and3_1
XFILLER_44_47 VSS VSS VDD VDD sky130_fd_sc_hd__decap_3
XTAP_TAPCELL_ROW_22_254 VSS VDD sky130_fd_sc_hd__tapvpwrvgnd_1
XFILLER_35_318 VSS VSS VDD VDD sky130_fd_sc_hd__decap_3
XFILLER_47_189 VSS VSS VDD VDD sky130_fd_sc_hd__fill_1
XFILLER_7_296 VSS VSS VDD VDD sky130_fd_sc_hd__fill_2
X_0612_ net123 net31 VSS VSS VDD VDD _0307_ sky130_fd_sc_hd__and2b_2
XFILLER_38_189 VSS VSS VDD VDD sky130_fd_sc_hd__fill_2
X_1026_ regs\[17\]\[5\] net162 _0571_ VSS VSS VDD VDD _0157_ sky130_fd_sc_hd__mux2_1
XFILLER_30_27 VSS VSS VDD VDD sky130_fd_sc_hd__fill_1
XTAP_TAPCELL_ROW_44_390 VSS VDD sky130_fd_sc_hd__tapvpwrvgnd_1
XFILLER_39_36 VSS VSS VDD VDD sky130_fd_sc_hd__decap_3
XFILLER_17_307 VSS VSS VDD VDD sky130_fd_sc_hd__decap_3
XFILLER_29_167 VSS VSS VDD VDD sky130_fd_sc_hd__fill_1
XFILLER_39_69 VSS VSS VDD VDD sky130_fd_sc_hd__fill_1
XFILLER_55_24 VSS VSS VDD VDD sky130_fd_sc_hd__decap_3
XFILLER_55_57 VSS VSS VDD VDD sky130_fd_sc_hd__decap_3
XFILLER_25_340 VSS VSS VDD VDD sky130_fd_sc_hd__decap_3
XFILLER_4_200 VSS VSS VDD VDD sky130_fd_sc_hd__decap_3
XFILLER_4_277 VSS VSS VDD VDD sky130_fd_sc_hd__fill_1
XPHY_EDGE_ROW_42_Left_100 VSS VSS VDD VDD sky130_fd_sc_hd__decap_3
XTAP_TAPCELL_ROW_41_371 VSS VDD sky130_fd_sc_hd__tapvpwrvgnd_1
XFILLER_26_104 VSS VSS VDD VDD sky130_fd_sc_hd__decap_3
XFILLER_26_126 VSS VSS VDD VDD sky130_fd_sc_hd__fill_2
XFILLER_25_27 VSS VSS VDD VDD sky130_fd_sc_hd__decap_3
XFILLER_34_181 VSS VSS VDD VDD sky130_fd_sc_hd__fill_2
XFILLER_41_118 VSS VSS VDD VDD sky130_fd_sc_hd__decap_3
X_1009_ regs\[15\]\[6\] net159 _0569_ VSS VSS VDD VDD _0142_ sky130_fd_sc_hd__mux2_1
XFILLER_41_15 VSS VSS VDD VDD sky130_fd_sc_hd__decap_3
XFILLER_1_225 VSS VSS VDD VDD sky130_fd_sc_hd__decap_3
XFILLER_9_6 VSS VSS VDD VDD sky130_fd_sc_hd__decap_3
XFILLER_17_137 VSS VSS VDD VDD sky130_fd_sc_hd__decap_3
XFILLER_57_240 VSS VSS VDD VDD sky130_fd_sc_hd__decap_3
XFILLER_57_284 VSS VSS VDD VDD sky130_fd_sc_hd__decap_3
XTAP_TAPCELL_ROW_55_452 VSS VDD sky130_fd_sc_hd__tapvpwrvgnd_1
XTAP_TAPCELL_ROW_47_408 VSS VDD sky130_fd_sc_hd__tapvpwrvgnd_1
XFILLER_15_71 VSS VSS VDD VDD sky130_fd_sc_hd__fill_1
XFILLER_25_181 VSS VSS VDD VDD sky130_fd_sc_hd__decap_3
XFILLER_31_70 VSS VSS VDD VDD sky130_fd_sc_hd__decap_3
X_1360_ net85 _0214_ net50 VSS VSS VDD VDD regs\[24\]\[6\] sky130_fd_sc_hd__dfrtp_1
XFILLER_48_262 VSS VSS VDD VDD sky130_fd_sc_hd__decap_3
X_1291_ net114 _0145_ net79 VSS VSS VDD VDD regs\[16\]\[1\] sky130_fd_sc_hd__dfrtp_1
XFILLER_11_18 VSS VSS VDD VDD sky130_fd_sc_hd__decap_3
XFILLER_31_184 VSS VSS VDD VDD sky130_fd_sc_hd__fill_1
XFILLER_36_15 VSS VSS VDD VDD sky130_fd_sc_hd__decap_3
XFILLER_39_251 VSS VSS VDD VDD sky130_fd_sc_hd__decap_3
XFILLER_54_221 VSS VSS VDD VDD sky130_fd_sc_hd__fill_2
XFILLER_54_243 VSS VSS VDD VDD sky130_fd_sc_hd__decap_3
XFILLER_54_276 VSS VSS VDD VDD sky130_fd_sc_hd__decap_3
XFILLER_22_195 VSS VSS VDD VDD sky130_fd_sc_hd__fill_1
XFILLER_52_25 VSS VSS VDD VDD sky130_fd_sc_hd__decap_3
XFILLER_52_47 VSS VSS VDD VDD sky130_fd_sc_hd__decap_3
XFILLER_7_3 VSS VSS VDD VDD sky130_fd_sc_hd__decap_3
XFILLER_45_210 VSS VSS VDD VDD sky130_fd_sc_hd__decap_3
XTAP_TAPCELL_ROW_9_177 VSS VDD sky130_fd_sc_hd__tapvpwrvgnd_1
XFILLER_26_81 VSS VSS VDD VDD sky130_fd_sc_hd__decap_3
XFILLER_45_265 VSS VSS VDD VDD sky130_fd_sc_hd__decap_3
X_0860_ net124 regs\[18\]\[7\] net35 VSS VSS VDD VDD _0548_ sky130_fd_sc_hd__and3_1
X_0791_ regs\[15\]\[5\] _0281_ _0478_ _0479_ _0480_ VSS VSS VDD VDD _0481_ sky130_fd_sc_hd__a2111o_1
XFILLER_3_30 VSS VSS VDD VDD sky130_fd_sc_hd__decap_3
XFILLER_3_63 VSS VSS VDD VDD sky130_fd_sc_hd__decap_3
X_1343_ net115 _0197_ net80 VSS VSS VDD VDD regs\[22\]\[5\] sky130_fd_sc_hd__dfrtp_1
XFILLER_36_221 VSS VSS VDD VDD sky130_fd_sc_hd__decap_3
XFILLER_3_85 VSS VSS VDD VDD sky130_fd_sc_hd__decap_3
XFILLER_51_202 VSS VSS VDD VDD sky130_fd_sc_hd__decap_3
X_1274_ net110 _0128_ net75 VSS VSS VDD VDD regs\[14\]\[0\] sky130_fd_sc_hd__dfrtp_1
X_0989_ regs\[13\]\[4\] net167 _0567_ VSS VSS VDD VDD _0124_ sky130_fd_sc_hd__mux2_1
XFILLER_47_36 VSS VSS VDD VDD sky130_fd_sc_hd__decap_3
Xfanout101 net107 VSS VSS VDD VDD net101 sky130_fd_sc_hd__clkbuf_2
Xfanout112 net116 VSS VSS VDD VDD net112 sky130_fd_sc_hd__clkbuf_2
Xfanout123 net138 VSS VSS VDD VDD net123 sky130_fd_sc_hd__buf_2
Xfanout134 net137 VSS VSS VDD VDD net134 sky130_fd_sc_hd__buf_1
Xfanout145 net147 VSS VSS VDD VDD net145 sky130_fd_sc_hd__buf_2
Xfanout156 net14 VSS VSS VDD VDD net156 sky130_fd_sc_hd__buf_2
Xfanout167 net12 VSS VSS VDD VDD net167 sky130_fd_sc_hd__buf_2
XTAP_TAPCELL_ROW_6_158 VSS VDD sky130_fd_sc_hd__tapvpwrvgnd_1
XFILLER_27_243 VSS VSS VDD VDD sky130_fd_sc_hd__decap_3
XFILLER_27_298 VSS VSS VDD VDD sky130_fd_sc_hd__decap_3
XFILLER_42_213 VSS VSS VDD VDD sky130_fd_sc_hd__fill_2
XFILLER_42_235 VSS VSS VDD VDD sky130_fd_sc_hd__decap_3
XFILLER_10_121 VSS VSS VDD VDD sky130_fd_sc_hd__fill_1
XFILLER_10_154 VSS VSS VDD VDD sky130_fd_sc_hd__decap_3
XFILLER_12_83 VSS VSS VDD VDD sky130_fd_sc_hd__fill_1
XFILLER_18_221 VSS VSS VDD VDD sky130_fd_sc_hd__fill_1
XFILLER_26_9 VSS VSS VDD VDD sky130_fd_sc_hd__decap_3
XFILLER_33_279 VSS VSS VDD VDD sky130_fd_sc_hd__fill_1
X_0912_ net150 _0291_ VSS VSS VDD VDD _0559_ sky130_fd_sc_hd__and2_4
XTAP_TAPCELL_ROW_28_293 VSS VDD sky130_fd_sc_hd__tapvpwrvgnd_1
X_0843_ net129 regs\[31\]\[7\] net38 _0332_ regs\[4\]\[7\] VSS VSS VDD VDD _0531_
+ sky130_fd_sc_hd__a32o_1
X_0774_ net146 net21 _0463_ _0464_ VSS VSS VDD VDD _0012_ sky130_fd_sc_hd__a22o_1
XTAP_TAPCELL_ROW_11_193 VSS VDD sky130_fd_sc_hd__tapvpwrvgnd_1
XFILLER_56_305 VSS VSS VDD VDD sky130_fd_sc_hd__decap_3
XFILLER_56_327 VSS VSS VDD VDD sky130_fd_sc_hd__decap_3
X_1326_ net108 _0180_ net73 VSS VSS VDD VDD regs\[20\]\[4\] sky130_fd_sc_hd__dfrtp_1
XFILLER_17_39 VSS VSS VDD VDD sky130_fd_sc_hd__decap_3
XFILLER_24_235 VSS VSS VDD VDD sky130_fd_sc_hd__fill_2
X_1257_ net84 _0111_ net49 VSS VSS VDD VDD regs\[11\]\[7\] sky130_fd_sc_hd__dfrtp_1
X_1188_ net112 _0042_ net77 VSS VSS VDD VDD regs\[3\]\[2\] sky130_fd_sc_hd__dfrtp_1
XFILLER_33_27 VSS VSS VDD VDD sky130_fd_sc_hd__decap_3
XFILLER_30_249 VSS VSS VDD VDD sky130_fd_sc_hd__decap_3
XTAP_TAPCELL_ROW_25_274 VSS VDD sky130_fd_sc_hd__tapvpwrvgnd_1
XFILLER_24_6 VSS VSS VDD VDD sky130_fd_sc_hd__decap_3
XFILLER_38_316 VSS VSS VDD VDD sky130_fd_sc_hd__decap_3
XFILLER_0_53 VSS VSS VDD VDD sky130_fd_sc_hd__decap_3
XFILLER_0_75 VSS VSS VDD VDD sky130_fd_sc_hd__decap_3
XFILLER_0_97 VSS VSS VDD VDD sky130_fd_sc_hd__decap_3
X_1111_ regs\[27\]\[0\] net44 _0272_ VSS VSS VDD VDD _0232_ sky130_fd_sc_hd__mux2_1
X_1042_ regs\[19\]\[3\] net171 _0264_ VSS VSS VDD VDD _0171_ sky130_fd_sc_hd__mux2_1
XFILLER_21_205 VSS VSS VDD VDD sky130_fd_sc_hd__decap_3
XFILLER_9_51 VSS VSS VDD VDD sky130_fd_sc_hd__decap_3
XFILLER_0_109 VSS VSS VDD VDD sky130_fd_sc_hd__decap_3
X_0826_ regs\[11\]\[6\] _0307_ _0320_ regs\[20\]\[6\] VSS VSS VDD VDD _0515_ sky130_fd_sc_hd__a22o_1
X_0757_ regs\[9\]\[4\] _0316_ _0445_ _0446_ _0447_ VSS VSS VDD VDD _0448_ sky130_fd_sc_hd__a2111o_1
X_0688_ net124 regs\[30\]\[2\] _0293_ VSS VSS VDD VDD _0381_ sky130_fd_sc_hd__and3_1
XFILLER_28_27 VSS VSS VDD VDD sky130_fd_sc_hd__fill_1
XFILLER_29_305 VSS VSS VDD VDD sky130_fd_sc_hd__decap_3
XFILLER_56_124 VSS VSS VDD VDD sky130_fd_sc_hd__decap_3
X_1309_ net98 _0163_ net63 VSS VSS VDD VDD regs\[18\]\[3\] sky130_fd_sc_hd__dfrtp_1
XFILLER_12_249 VSS VSS VDD VDD sky130_fd_sc_hd__decap_3
XFILLER_44_15 VSS VSS VDD VDD sky130_fd_sc_hd__decap_3
XFILLER_52_341 VSS VSS VDD VDD sky130_fd_sc_hd__decap_3
XFILLER_20_271 VSS VSS VDD VDD sky130_fd_sc_hd__decap_3
XTAP_TAPCELL_ROW_22_255 VSS VDD sky130_fd_sc_hd__tapvpwrvgnd_1
XFILLER_47_102 VSS VSS VDD VDD sky130_fd_sc_hd__decap_3
XFILLER_47_113 VSS VSS VDD VDD sky130_fd_sc_hd__decap_3
XFILLER_18_71 VSS VSS VDD VDD sky130_fd_sc_hd__decap_3
XFILLER_35_308 VSS VSS VDD VDD sky130_fd_sc_hd__fill_1
XFILLER_43_341 VSS VSS VDD VDD sky130_fd_sc_hd__decap_3
XFILLER_11_293 VSS VSS VDD VDD sky130_fd_sc_hd__decap_3
XFILLER_34_81 VSS VSS VDD VDD sky130_fd_sc_hd__decap_3
XTAP_TAPCELL_ROW_13_200 VSS VDD sky130_fd_sc_hd__tapvpwrvgnd_1
XFILLER_50_80 VSS VSS VDD VDD sky130_fd_sc_hd__decap_3
X_0611_ net141 net139 net143 net175 VSS VSS VDD VDD _0306_ sky130_fd_sc_hd__and4b_2
XFILLER_22_3 VSS VSS VDD VDD sky130_fd_sc_hd__decap_3
XFILLER_14_18 VSS VSS VDD VDD sky130_fd_sc_hd__decap_3
XFILLER_14_29 VSS VSS VDD VDD sky130_fd_sc_hd__decap_3
XFILLER_53_138 VSS VSS VDD VDD sky130_fd_sc_hd__decap_3
X_1025_ regs\[17\]\[4\] net164 _0571_ VSS VSS VDD VDD _0156_ sky130_fd_sc_hd__mux2_1
XTAP_TAPCELL_ROW_44_391 VSS VDD sky130_fd_sc_hd__tapvpwrvgnd_1
X_0809_ net117 regs\[29\]\[6\] net30 VSS VSS VDD VDD _0498_ sky130_fd_sc_hd__and3_1
XFILLER_39_15 VSS VSS VDD VDD sky130_fd_sc_hd__decap_3
XFILLER_39_48 VSS VSS VDD VDD sky130_fd_sc_hd__decap_3
XFILLER_44_127 VSS VSS VDD VDD sky130_fd_sc_hd__decap_3
XFILLER_55_36 VSS VSS VDD VDD sky130_fd_sc_hd__decap_3
XFILLER_55_69 VSS VSS VDD VDD sky130_fd_sc_hd__decap_3
XFILLER_52_193 VSS VSS VDD VDD sky130_fd_sc_hd__decap_3
XFILLER_4_223 VSS VSS VDD VDD sky130_fd_sc_hd__decap_3
XFILLER_29_81 VSS VSS VDD VDD sky130_fd_sc_hd__decap_3
XFILLER_31_322 VSS VSS VDD VDD sky130_fd_sc_hd__decap_3
XFILLER_45_80 VSS VSS VDD VDD sky130_fd_sc_hd__decap_3
XANTENNA_1 _0285_ VSS VSS VDD VDD sky130_fd_sc_hd__diode_2
XFILLER_6_41 VSS VSS VDD VDD sky130_fd_sc_hd__decap_3
XTAP_TAPCELL_ROW_41_372 VSS VDD sky130_fd_sc_hd__tapvpwrvgnd_1
XFILLER_19_190 VSS VSS VDD VDD sky130_fd_sc_hd__decap_3
XFILLER_26_138 VSS VSS VDD VDD sky130_fd_sc_hd__fill_2
XFILLER_22_300 VSS VSS VDD VDD sky130_fd_sc_hd__decap_3
XFILLER_25_39 VSS VSS VDD VDD sky130_fd_sc_hd__decap_3
XFILLER_34_171 VSS VSS VDD VDD sky130_fd_sc_hd__fill_1
XFILLER_41_108 VSS VSS VDD VDD sky130_fd_sc_hd__decap_3
XFILLER_41_27 VSS VSS VDD VDD sky130_fd_sc_hd__decap_3
X_1008_ regs\[15\]\[5\] net162 _0569_ VSS VSS VDD VDD _0141_ sky130_fd_sc_hd__mux2_1
XFILLER_41_49 VSS VSS VDD VDD sky130_fd_sc_hd__decap_3
XFILLER_49_208 VSS VSS VDD VDD sky130_fd_sc_hd__decap_3
XFILLER_49_219 VSS VSS VDD VDD sky130_fd_sc_hd__decap_3
XTAP_TAPCELL_ROW_47_409 VSS VDD sky130_fd_sc_hd__tapvpwrvgnd_1
XFILLER_13_311 VSS VSS VDD VDD sky130_fd_sc_hd__decap_3
XFILLER_17_149 VSS VSS VDD VDD sky130_fd_sc_hd__decap_3
XFILLER_57_274 VSS VSS VDD VDD sky130_fd_sc_hd__fill_2
XFILLER_57_296 VSS VSS VDD VDD sky130_fd_sc_hd__decap_3
XTAP_TAPCELL_ROW_55_453 VSS VDD sky130_fd_sc_hd__tapvpwrvgnd_1
XFILLER_31_60 VSS VSS VDD VDD sky130_fd_sc_hd__fill_1
XFILLER_40_130 VSS VSS VDD VDD sky130_fd_sc_hd__decap_3
XFILLER_40_141 VSS VSS VDD VDD sky130_fd_sc_hd__decap_3
XFILLER_9_337 VSS VSS VDD VDD sky130_fd_sc_hd__decap_3
XFILLER_56_9 VSS VSS VDD VDD sky130_fd_sc_hd__decap_3
XFILLER_0_281 VSS VSS VDD VDD sky130_fd_sc_hd__decap_3
XFILLER_48_274 VSS VSS VDD VDD sky130_fd_sc_hd__decap_3
X_1290_ net98 _0144_ net63 VSS VSS VDD VDD regs\[16\]\[0\] sky130_fd_sc_hd__dfrtp_1
XFILLER_16_171 VSS VSS VDD VDD sky130_fd_sc_hd__fill_1
XFILLER_31_130 VSS VSS VDD VDD sky130_fd_sc_hd__fill_2
XFILLER_31_152 VSS VSS VDD VDD sky130_fd_sc_hd__decap_3
XFILLER_36_27 VSS VSS VDD VDD sky130_fd_sc_hd__fill_1
XFILLER_39_263 VSS VSS VDD VDD sky130_fd_sc_hd__decap_3
XFILLER_54_200 VSS VSS VDD VDD sky130_fd_sc_hd__decap_3
XFILLER_54_288 VSS VSS VDD VDD sky130_fd_sc_hd__fill_1
XTAP_TAPCELL_ROW_52_434 VSS VDD sky130_fd_sc_hd__tapvpwrvgnd_1
XFILLER_10_303 VSS VSS VDD VDD sky130_fd_sc_hd__decap_3
XFILLER_22_141 VSS VSS VDD VDD sky130_fd_sc_hd__decap_3
XFILLER_22_163 VSS VSS VDD VDD sky130_fd_sc_hd__fill_2
XFILLER_52_59 VSS VSS VDD VDD sky130_fd_sc_hd__decap_3
XTAP_TAPCELL_ROW_9_178 VSS VDD sky130_fd_sc_hd__tapvpwrvgnd_1
XFILLER_13_141 VSS VSS VDD VDD sky130_fd_sc_hd__fill_2
XFILLER_13_152 VSS VSS VDD VDD sky130_fd_sc_hd__decap_3
XFILLER_13_163 VSS VSS VDD VDD sky130_fd_sc_hd__decap_3
XFILLER_45_277 VSS VSS VDD VDD sky130_fd_sc_hd__decap_3
X_0790_ net136 regs\[18\]\[5\] _0288_ VSS VSS VDD VDD _0480_ sky130_fd_sc_hd__and3_1
XFILLER_9_178 VSS VSS VDD VDD sky130_fd_sc_hd__decap_3
XFILLER_9_167 VSS VSS VDD VDD sky130_fd_sc_hd__fill_1
XFILLER_3_42 VSS VSS VDD VDD sky130_fd_sc_hd__decap_3
X_1273_ net87 _0127_ net52 VSS VSS VDD VDD regs\[13\]\[7\] sky130_fd_sc_hd__dfrtp_1
X_1342_ net115 _0196_ net80 VSS VSS VDD VDD regs\[22\]\[4\] sky130_fd_sc_hd__dfrtp_1
XFILLER_36_200 VSS VSS VDD VDD sky130_fd_sc_hd__decap_3
XFILLER_36_266 VSS VSS VDD VDD sky130_fd_sc_hd__fill_1
XFILLER_22_18 VSS VSS VDD VDD sky130_fd_sc_hd__decap_3
XFILLER_22_29 VSS VSS VDD VDD sky130_fd_sc_hd__decap_3
X_0988_ regs\[13\]\[3\] net168 _0567_ VSS VSS VDD VDD _0123_ sky130_fd_sc_hd__mux2_1
Xfanout102 net107 VSS VSS VDD VDD net102 sky130_fd_sc_hd__clkbuf_2
Xfanout113 net116 VSS VSS VDD VDD net113 sky130_fd_sc_hd__buf_1
XFILLER_27_222 VSS VSS VDD VDD sky130_fd_sc_hd__fill_2
XFILLER_47_15 VSS VSS VDD VDD sky130_fd_sc_hd__decap_3
XFILLER_47_48 VSS VSS VDD VDD sky130_fd_sc_hd__decap_3
Xfanout124 net138 VSS VSS VDD VDD net124 sky130_fd_sc_hd__buf_2
Xfanout135 net137 VSS VSS VDD VDD net135 sky130_fd_sc_hd__clkbuf_2
Xfanout146 net147 VSS VSS VDD VDD net146 sky130_fd_sc_hd__clkbuf_2
Xfanout157 net14 VSS VSS VDD VDD net157 sky130_fd_sc_hd__clkbuf_2
Xfanout168 net11 VSS VSS VDD VDD net168 sky130_fd_sc_hd__clkbuf_4
XTAP_TAPCELL_ROW_6_159 VSS VDD sky130_fd_sc_hd__tapvpwrvgnd_1
XFILLER_27_255 VSS VSS VDD VDD sky130_fd_sc_hd__decap_3
XFILLER_27_277 VSS VSS VDD VDD sky130_fd_sc_hd__decap_3
XFILLER_42_247 VSS VSS VDD VDD sky130_fd_sc_hd__decap_3
XFILLER_10_166 VSS VSS VDD VDD sky130_fd_sc_hd__decap_3
XFILLER_6_137 VSS VSS VDD VDD sky130_fd_sc_hd__decap_3
XFILLER_6_159 VSS VSS VDD VDD sky130_fd_sc_hd__fill_2
XFILLER_18_266 VSS VSS VDD VDD sky130_fd_sc_hd__decap_3
XFILLER_19_9 VSS VSS VDD VDD sky130_fd_sc_hd__decap_3
XFILLER_33_225 VSS VSS VDD VDD sky130_fd_sc_hd__decap_3
X_0911_ net155 regs\[4\]\[7\] _0558_ VSS VSS VDD VDD _0055_ sky130_fd_sc_hd__mux2_1
X_0842_ _0526_ _0527_ _0528_ _0529_ VSS VSS VDD VDD _0530_ sky130_fd_sc_hd__or4_1
XTAP_TAPCELL_ROW_28_294 VSS VDD sky130_fd_sc_hd__tapvpwrvgnd_1
XFILLER_5_192 VSS VSS VDD VDD sky130_fd_sc_hd__fill_2
X_0773_ regs\[0\]\[4\] _0327_ net145 VSS VSS VDD VDD _0464_ sky130_fd_sc_hd__o21ba_1
XFILLER_17_18 VSS VSS VDD VDD sky130_fd_sc_hd__decap_3
XFILLER_56_339 VSS VSS VDD VDD sky130_fd_sc_hd__decap_3
X_1256_ net96 _0110_ net61 VSS VSS VDD VDD regs\[11\]\[6\] sky130_fd_sc_hd__dfrtp_1
X_1325_ net105 _0179_ net70 VSS VSS VDD VDD regs\[20\]\[3\] sky130_fd_sc_hd__dfrtp_1
XFILLER_24_269 VSS VSS VDD VDD sky130_fd_sc_hd__decap_3
XFILLER_33_39 VSS VSS VDD VDD sky130_fd_sc_hd__decap_3
X_1187_ net91 _0041_ net56 VSS VSS VDD VDD regs\[3\]\[1\] sky130_fd_sc_hd__dfrtp_1
XFILLER_3_107 VSS VSS VDD VDD sky130_fd_sc_hd__decap_3
XFILLER_15_225 VSS VSS VDD VDD sky130_fd_sc_hd__decap_3
XFILLER_47_306 VSS VSS VDD VDD sky130_fd_sc_hd__fill_1
XFILLER_15_269 VSS VSS VDD VDD sky130_fd_sc_hd__decap_3
XTAP_TAPCELL_ROW_25_275 VSS VDD sky130_fd_sc_hd__tapvpwrvgnd_1
XFILLER_17_6 VSS VSS VDD VDD sky130_fd_sc_hd__decap_3
XFILLER_2_195 VSS VSS VDD VDD sky130_fd_sc_hd__fill_1
XFILLER_38_306 VSS VSS VDD VDD sky130_fd_sc_hd__fill_2
XFILLER_48_80 VSS VSS VDD VDD sky130_fd_sc_hd__decap_3
X_1110_ net123 net145 net31 VSS VSS VDD VDD _0272_ sky130_fd_sc_hd__and3_4
XFILLER_0_21 VSS VSS VDD VDD sky130_fd_sc_hd__decap_3
XFILLER_0_32 VSS VSS VDD VDD sky130_fd_sc_hd__decap_3
XFILLER_21_217 VSS VSS VDD VDD sky130_fd_sc_hd__decap_3
X_1041_ regs\[19\]\[2\] net172 _0264_ VSS VSS VDD VDD _0170_ sky130_fd_sc_hd__mux2_1
XTAP_TAPCELL_ROW_16_220 VSS VDD sky130_fd_sc_hd__tapvpwrvgnd_1
XFILLER_9_30 VSS VSS VDD VDD sky130_fd_sc_hd__decap_3
X_0825_ regs\[16\]\[6\] net26 _0326_ _0513_ VSS VSS VDD VDD _0514_ sky130_fd_sc_hd__a211o_1
X_0756_ net125 regs\[13\]\[4\] net30 VSS VSS VDD VDD _0447_ sky130_fd_sc_hd__and3b_1
X_0687_ net123 regs\[16\]\[2\] net26 VSS VSS VDD VDD _0380_ sky130_fd_sc_hd__and3_1
XFILLER_44_309 VSS VSS VDD VDD sky130_fd_sc_hd__fill_2
XFILLER_52_320 VSS VSS VDD VDD sky130_fd_sc_hd__decap_3
XFILLER_56_103 VSS VSS VDD VDD sky130_fd_sc_hd__decap_3
XFILLER_56_136 VSS VSS VDD VDD sky130_fd_sc_hd__decap_3
X_1239_ net82 _0093_ net47 VSS VSS VDD VDD regs\[9\]\[5\] sky130_fd_sc_hd__dfrtp_1
X_1308_ net111 _0162_ net76 VSS VSS VDD VDD regs\[18\]\[2\] sky130_fd_sc_hd__dfrtp_1
XTAP_TAPCELL_ROW_39_356 VSS VDD sky130_fd_sc_hd__tapvpwrvgnd_1
XFILLER_44_27 VSS VSS VDD VDD sky130_fd_sc_hd__fill_1
XFILLER_44_38 VSS VSS VDD VDD sky130_fd_sc_hd__decap_3
XTAP_TAPCELL_ROW_22_256 VSS VDD sky130_fd_sc_hd__tapvpwrvgnd_1
XPHY_EDGE_ROW_8_Left_66 VSS VSS VDD VDD sky130_fd_sc_hd__decap_3
XFILLER_18_50 VSS VSS VDD VDD sky130_fd_sc_hd__decap_3
XFILLER_47_169 VSS VSS VDD VDD sky130_fd_sc_hd__fill_2
XFILLER_7_221 VSS VSS VDD VDD sky130_fd_sc_hd__decap_3
XTAP_TAPCELL_ROW_13_201 VSS VDD sky130_fd_sc_hd__tapvpwrvgnd_1
XFILLER_7_276 VSS VSS VDD VDD sky130_fd_sc_hd__decap_3
XFILLER_7_287 VSS VSS VDD VDD sky130_fd_sc_hd__decap_3
X_0610_ net119 regs\[7\]\[0\] _0303_ VSS VSS VDD VDD _0305_ sky130_fd_sc_hd__and3b_1
XFILLER_15_3 VSS VSS VDD VDD sky130_fd_sc_hd__decap_3
XFILLER_38_103 VSS VSS VDD VDD sky130_fd_sc_hd__decap_3
X_1024_ regs\[17\]\[3\] net170 _0571_ VSS VSS VDD VDD _0155_ sky130_fd_sc_hd__mux2_1
XFILLER_34_342 VSS VSS VDD VDD sky130_fd_sc_hd__fill_2
XFILLER_30_18 VSS VSS VDD VDD sky130_fd_sc_hd__decap_3
XFILLER_30_29 VSS VSS VDD VDD sky130_fd_sc_hd__decap_3
X_0808_ net118 regs\[24\]\[6\] net25 VSS VSS VDD VDD _0497_ sky130_fd_sc_hd__and3_1
XFILLER_39_27 VSS VSS VDD VDD sky130_fd_sc_hd__decap_3
X_0739_ regs\[3\]\[3\] _0284_ _0428_ _0429_ _0430_ VSS VSS VDD VDD _0431_ sky130_fd_sc_hd__a2111o_1
XFILLER_44_139 VSS VSS VDD VDD sky130_fd_sc_hd__fill_1
XFILLER_52_161 VSS VSS VDD VDD sky130_fd_sc_hd__fill_2
XFILLER_55_15 VSS VSS VDD VDD sky130_fd_sc_hd__decap_3
XFILLER_55_48 VSS VSS VDD VDD sky130_fd_sc_hd__decap_3
XFILLER_52_183 VSS VSS VDD VDD sky130_fd_sc_hd__decap_3
XFILLER_20_95 VSS VSS VDD VDD sky130_fd_sc_hd__decap_3
XFILLER_4_268 VSS VSS VDD VDD sky130_fd_sc_hd__decap_3
XFILLER_29_60 VSS VSS VDD VDD sky130_fd_sc_hd__decap_3
XFILLER_31_334 VSS VSS VDD VDD sky130_fd_sc_hd__fill_2
XFILLER_45_92 VSS VSS VDD VDD sky130_fd_sc_hd__decap_3
XANTENNA_2 _0285_ VSS VSS VDD VDD sky130_fd_sc_hd__diode_2
XFILLER_6_53 VSS VSS VDD VDD sky130_fd_sc_hd__decap_3
XTAP_TAPCELL_ROW_41_373 VSS VDD sky130_fd_sc_hd__tapvpwrvgnd_1
XFILLER_25_18 VSS VSS VDD VDD sky130_fd_sc_hd__decap_3
XFILLER_34_150 VSS VSS VDD VDD sky130_fd_sc_hd__decap_3
X_1007_ regs\[15\]\[4\] net166 _0569_ VSS VSS VDD VDD _0140_ sky130_fd_sc_hd__mux2_1
XFILLER_41_39 VSS VSS VDD VDD sky130_fd_sc_hd__decap_3
XFILLER_17_106 VSS VSS VDD VDD sky130_fd_sc_hd__decap_3
XFILLER_57_253 VSS VSS VDD VDD sky130_fd_sc_hd__decap_3
XFILLER_15_51 VSS VSS VDD VDD sky130_fd_sc_hd__decap_3
XFILLER_17_128 VSS VSS VDD VDD sky130_fd_sc_hd__decap_3
XFILLER_25_161 VSS VSS VDD VDD sky130_fd_sc_hd__decap_3
XFILLER_25_194 VSS VSS VDD VDD sky130_fd_sc_hd__decap_3
XTAP_TAPCELL_ROW_55_454 VSS VDD sky130_fd_sc_hd__tapvpwrvgnd_1
XFILLER_40_197 VSS VSS VDD VDD sky130_fd_sc_hd__decap_3
XFILLER_49_9 VSS VSS VDD VDD sky130_fd_sc_hd__decap_3
XFILLER_0_293 VSS VSS VDD VDD sky130_fd_sc_hd__decap_3
XFILLER_23_109 VSS VSS VDD VDD sky130_fd_sc_hd__decap_3
XFILLER_48_253 VSS VSS VDD VDD sky130_fd_sc_hd__fill_2
XFILLER_48_286 VSS VSS VDD VDD sky130_fd_sc_hd__decap_3
XFILLER_56_80 VSS VSS VDD VDD sky130_fd_sc_hd__decap_3
XFILLER_56_91 VSS VSS VDD VDD sky130_fd_sc_hd__decap_3
XFILLER_31_175 VSS VSS VDD VDD sky130_fd_sc_hd__fill_1
XFILLER_39_275 VSS VSS VDD VDD sky130_fd_sc_hd__decap_3
XFILLER_54_212 VSS VSS VDD VDD sky130_fd_sc_hd__decap_3
XFILLER_14_109 VSS VSS VDD VDD sky130_fd_sc_hd__decap_3
XFILLER_52_16 VSS VSS VDD VDD sky130_fd_sc_hd__decap_3
XFILLER_52_38 VSS VSS VDD VDD sky130_fd_sc_hd__decap_3
XFILLER_54_234 VSS VSS VDD VDD sky130_fd_sc_hd__decap_3
XTAP_TAPCELL_ROW_52_435 VSS VDD sky130_fd_sc_hd__tapvpwrvgnd_1
XFILLER_22_197 VSS VSS VDD VDD sky130_fd_sc_hd__decap_3
XTAP_TAPCELL_ROW_9_179 VSS VDD sky130_fd_sc_hd__tapvpwrvgnd_1
XFILLER_45_223 VSS VSS VDD VDD sky130_fd_sc_hd__fill_1
XFILLER_45_256 VSS VSS VDD VDD sky130_fd_sc_hd__decap_3
XPHY_EDGE_ROW_37_Left_95 VSS VSS VDD VDD sky130_fd_sc_hd__decap_3
XFILLER_13_175 VSS VSS VDD VDD sky130_fd_sc_hd__decap_3
XFILLER_9_146 VSS VSS VDD VDD sky130_fd_sc_hd__decap_3
XFILLER_42_82 VSS VSS VDD VDD sky130_fd_sc_hd__fill_2
XFILLER_47_6 VSS VSS VDD VDD sky130_fd_sc_hd__decap_3
XFILLER_54_7 VSS VSS VDD VDD sky130_fd_sc_hd__decap_3
XPHY_EDGE_ROW_21_Left_79 VSS VSS VDD VDD sky130_fd_sc_hd__decap_3
XFILLER_3_21 VSS VSS VDD VDD sky130_fd_sc_hd__decap_3
XFILLER_3_54 VSS VSS VDD VDD sky130_fd_sc_hd__fill_2
X_1272_ net82 _0126_ net47 VSS VSS VDD VDD regs\[13\]\[6\] sky130_fd_sc_hd__dfrtp_1
X_1341_ net113 _0195_ net78 VSS VSS VDD VDD regs\[22\]\[3\] sky130_fd_sc_hd__dfrtp_1
XFILLER_36_212 VSS VSS VDD VDD sky130_fd_sc_hd__decap_3
Xwire27 _0325_ VSS VSS VDD VDD net27 sky130_fd_sc_hd__clkbuf_1
X_0987_ regs\[13\]\[2\] net174 _0567_ VSS VSS VDD VDD _0122_ sky130_fd_sc_hd__mux2_1
Xfanout103 net107 VSS VSS VDD VDD net103 sky130_fd_sc_hd__clkbuf_1
Xfanout114 net116 VSS VSS VDD VDD net114 sky130_fd_sc_hd__clkbuf_2
Xfanout125 net127 VSS VSS VDD VDD net125 sky130_fd_sc_hd__clkbuf_2
Xfanout136 net137 VSS VSS VDD VDD net136 sky130_fd_sc_hd__buf_1
Xfanout147 net148 VSS VSS VDD VDD net147 sky130_fd_sc_hd__buf_2
XFILLER_47_27 VSS VSS VDD VDD sky130_fd_sc_hd__decap_3
Xfanout158 net14 VSS VSS VDD VDD net158 sky130_fd_sc_hd__buf_2
Xfanout169 net11 VSS VSS VDD VDD net169 sky130_fd_sc_hd__clkbuf_2
XFILLER_10_134 VSS VSS VDD VDD sky130_fd_sc_hd__decap_3
XFILLER_27_289 VSS VSS VDD VDD sky130_fd_sc_hd__decap_3
XFILLER_42_204 VSS VSS VDD VDD sky130_fd_sc_hd__decap_3
XFILLER_42_259 VSS VSS VDD VDD sky130_fd_sc_hd__decap_3
XFILLER_10_178 VSS VSS VDD VDD sky130_fd_sc_hd__decap_3
XFILLER_10_189 VSS VSS VDD VDD sky130_fd_sc_hd__decap_3
XFILLER_12_85 VSS VSS VDD VDD sky130_fd_sc_hd__decap_3
XFILLER_18_212 VSS VSS VDD VDD sky130_fd_sc_hd__decap_3
XFILLER_18_278 VSS VSS VDD VDD sky130_fd_sc_hd__decap_3
XFILLER_37_60 VSS VSS VDD VDD sky130_fd_sc_hd__decap_3
XTAP_TAPCELL_ROW_28_295 VSS VDD sky130_fd_sc_hd__tapvpwrvgnd_1
XPHY_EDGE_ROW_16_Right_16 VSS VSS VDD VDD sky130_fd_sc_hd__decap_3
XFILLER_53_81 VSS VSS VDD VDD sky130_fd_sc_hd__decap_3
X_0910_ net158 regs\[4\]\[6\] _0558_ VSS VSS VDD VDD _0054_ sky130_fd_sc_hd__mux2_1
X_0841_ net124 regs\[16\]\[7\] net26 _0281_ regs\[15\]\[7\] VSS VSS VDD VDD _0529_
+ sky130_fd_sc_hd__a32o_1
X_0772_ _0449_ _0455_ _0462_ VSS VSS VDD VDD _0463_ sky130_fd_sc_hd__or3_1
XPHY_EDGE_ROW_25_Right_25 VSS VSS VDD VDD sky130_fd_sc_hd__decap_3
XFILLER_45_3 VSS VSS VDD VDD sky130_fd_sc_hd__decap_3
XFILLER_56_318 VSS VSS VDD VDD sky130_fd_sc_hd__decap_3
X_1255_ net91 _0109_ net56 VSS VSS VDD VDD regs\[11\]\[5\] sky130_fd_sc_hd__dfrtp_1
X_1324_ net112 _0178_ net77 VSS VSS VDD VDD regs\[20\]\[2\] sky130_fd_sc_hd__dfrtp_1
X_1186_ net102 _0040_ net67 VSS VSS VDD VDD regs\[3\]\[0\] sky130_fd_sc_hd__dfrtp_1
XTAP_TAPCELL_ROW_19_240 VSS VDD sky130_fd_sc_hd__tapvpwrvgnd_1
XPHY_EDGE_ROW_34_Right_34 VSS VSS VDD VDD sky130_fd_sc_hd__decap_3
XFILLER_24_226 VSS VSS VDD VDD sky130_fd_sc_hd__decap_3
XFILLER_33_18 VSS VSS VDD VDD sky130_fd_sc_hd__decap_3
XFILLER_3_119 VSS VSS VDD VDD sky130_fd_sc_hd__decap_3
XPHY_EDGE_ROW_43_Right_43 VSS VSS VDD VDD sky130_fd_sc_hd__decap_3
XPHY_EDGE_ROW_52_Right_52 VSS VSS VDD VDD sky130_fd_sc_hd__decap_3
XFILLER_15_248 VSS VSS VDD VDD sky130_fd_sc_hd__decap_3
XFILLER_15_259 VSS VSS VDD VDD sky130_fd_sc_hd__fill_1
XFILLER_55_340 VSS VSS VDD VDD sky130_fd_sc_hd__decap_3
XFILLER_23_281 VSS VSS VDD VDD sky130_fd_sc_hd__fill_1
XTAP_TAPCELL_ROW_25_276 VSS VDD sky130_fd_sc_hd__tapvpwrvgnd_1
XFILLER_2_141 VSS VSS VDD VDD sky130_fd_sc_hd__decap_3
XFILLER_31_9 VSS VSS VDD VDD sky130_fd_sc_hd__decap_3
XFILLER_0_44 VSS VSS VDD VDD sky130_fd_sc_hd__decap_3
X_1040_ regs\[19\]\[1\] net40 _0264_ VSS VSS VDD VDD _0169_ sky130_fd_sc_hd__mux2_1
XFILLER_0_66 VSS VSS VDD VDD sky130_fd_sc_hd__decap_3
XFILLER_0_88 VSS VSS VDD VDD sky130_fd_sc_hd__decap_3
XTAP_TAPCELL_ROW_16_221 VSS VDD sky130_fd_sc_hd__tapvpwrvgnd_1
XFILLER_9_42 VSS VSS VDD VDD sky130_fd_sc_hd__decap_3
X_0824_ net124 regs\[30\]\[6\] net33 VSS VSS VDD VDD _0513_ sky130_fd_sc_hd__and3_1
X_0755_ net125 regs\[14\]\[4\] net33 VSS VSS VDD VDD _0446_ sky130_fd_sc_hd__and3b_1
XPHY_EDGE_ROW_24_Left_82 VSS VSS VDD VDD sky130_fd_sc_hd__decap_3
XFILLER_28_18 VSS VSS VDD VDD sky130_fd_sc_hd__decap_3
XFILLER_28_29 VSS VSS VDD VDD sky130_fd_sc_hd__decap_3
X_0686_ regs\[3\]\[2\] _0284_ _0376_ _0377_ _0378_ VSS VSS VDD VDD _0379_ sky130_fd_sc_hd__a2111o_1
XFILLER_52_332 VSS VSS VDD VDD sky130_fd_sc_hd__decap_3
XFILLER_56_115 VSS VSS VDD VDD sky130_fd_sc_hd__decap_3
X_1238_ net100 _0092_ net65 VSS VSS VDD VDD regs\[9\]\[4\] sky130_fd_sc_hd__dfrtp_1
X_1307_ net114 _0161_ net79 VSS VSS VDD VDD regs\[18\]\[1\] sky130_fd_sc_hd__dfrtp_1
X_1169_ net98 _0023_ net63 VSS VSS VDD VDD regs\[0\]\[7\] sky130_fd_sc_hd__dfrtp_1
XTAP_TAPCELL_ROW_39_357 VSS VDD sky130_fd_sc_hd__tapvpwrvgnd_1
XFILLER_20_262 VSS VSS VDD VDD sky130_fd_sc_hd__decap_3
XTAP_TAPCELL_ROW_22_257 VSS VDD sky130_fd_sc_hd__tapvpwrvgnd_1
XFILLER_18_62 VSS VSS VDD VDD sky130_fd_sc_hd__decap_3
XFILLER_34_72 VSS VSS VDD VDD sky130_fd_sc_hd__decap_3
XFILLER_55_181 VSS VSS VDD VDD sky130_fd_sc_hd__fill_1
XTAP_TAPCELL_ROW_13_202 VSS VDD sky130_fd_sc_hd__tapvpwrvgnd_1
XFILLER_11_273 VSS VSS VDD VDD sky130_fd_sc_hd__decap_3
XFILLER_50_71 VSS VSS VDD VDD sky130_fd_sc_hd__decap_3
XFILLER_38_137 VSS VSS VDD VDD sky130_fd_sc_hd__decap_3
X_1023_ regs\[17\]\[2\] net172 _0571_ VSS VSS VDD VDD _0154_ sky130_fd_sc_hd__mux2_1
XTAP_TAPCELL_ROW_36_338 VSS VDD sky130_fd_sc_hd__tapvpwrvgnd_1
X_0807_ net117 regs\[7\]\[6\] _0303_ VSS VSS VDD VDD _0496_ sky130_fd_sc_hd__and3b_1
X_0738_ net129 regs\[27\]\[3\] _0306_ VSS VSS VDD VDD _0430_ sky130_fd_sc_hd__and3_1
XFILLER_39_39 VSS VSS VDD VDD sky130_fd_sc_hd__decap_3
X_0669_ net126 regs\[30\]\[1\] net33 VSS VSS VDD VDD _0363_ sky130_fd_sc_hd__and3_1
XPHY_EDGE_ROW_2_Right_2 VSS VSS VDD VDD sky130_fd_sc_hd__decap_3
XFILLER_25_321 VSS VSS VDD VDD sky130_fd_sc_hd__decap_3
XFILLER_25_343 VSS VSS VDD VDD sky130_fd_sc_hd__fill_1
XFILLER_40_302 VSS VSS VDD VDD sky130_fd_sc_hd__fill_1
XFILLER_55_27 VSS VSS VDD VDD sky130_fd_sc_hd__decap_3
XFILLER_4_203 VSS VSS VDD VDD sky130_fd_sc_hd__fill_1
XFILLER_35_118 VSS VSS VDD VDD sky130_fd_sc_hd__decap_3
XFILLER_31_302 VSS VSS VDD VDD sky130_fd_sc_hd__decap_3
XFILLER_45_60 VSS VSS VDD VDD sky130_fd_sc_hd__decap_3
XANTENNA_3 _0298_ VSS VSS VDD VDD sky130_fd_sc_hd__diode_2
XFILLER_6_21 VSS VSS VDD VDD sky130_fd_sc_hd__decap_3
XFILLER_6_32 VSS VSS VDD VDD sky130_fd_sc_hd__decap_3
XFILLER_19_181 VSS VSS VDD VDD sky130_fd_sc_hd__decap_3
XFILLER_26_107 VSS VSS VDD VDD sky130_fd_sc_hd__decap_3
XFILLER_34_162 VSS VSS VDD VDD sky130_fd_sc_hd__decap_3
X_1006_ regs\[15\]\[3\] net168 _0569_ VSS VSS VDD VDD _0139_ sky130_fd_sc_hd__mux2_1
XFILLER_41_18 VSS VSS VDD VDD sky130_fd_sc_hd__decap_3
XFILLER_1_228 VSS VSS VDD VDD sky130_fd_sc_hd__decap_3
XFILLER_9_9 VSS VSS VDD VDD sky130_fd_sc_hd__decap_3
XFILLER_57_221 VSS VSS VDD VDD sky130_fd_sc_hd__decap_3
XFILLER_57_243 VSS VSS VDD VDD sky130_fd_sc_hd__decap_3
XFILLER_57_265 VSS VSS VDD VDD sky130_fd_sc_hd__decap_3
XFILLER_57_287 VSS VSS VDD VDD sky130_fd_sc_hd__decap_3
XFILLER_15_30 VSS VSS VDD VDD sky130_fd_sc_hd__decap_3
XFILLER_25_140 VSS VSS VDD VDD sky130_fd_sc_hd__fill_1
XFILLER_25_184 VSS VSS VDD VDD sky130_fd_sc_hd__decap_3
XTAP_TAPCELL_ROW_55_455 VSS VDD sky130_fd_sc_hd__tapvpwrvgnd_1
XFILLER_31_73 VSS VSS VDD VDD sky130_fd_sc_hd__fill_2
XFILLER_40_187 VSS VSS VDD VDD sky130_fd_sc_hd__fill_2
XFILLER_0_250 VSS VSS VDD VDD sky130_fd_sc_hd__fill_2
XFILLER_0_272 VSS VSS VDD VDD sky130_fd_sc_hd__decap_3
XFILLER_48_265 VSS VSS VDD VDD sky130_fd_sc_hd__decap_3
XTAP_TAPCELL_ROW_46_400 VSS VDD sky130_fd_sc_hd__tapvpwrvgnd_1
XFILLER_36_18 VSS VSS VDD VDD sky130_fd_sc_hd__decap_3
XFILLER_36_29 VSS VSS VDD VDD sky130_fd_sc_hd__decap_3
XFILLER_39_221 VSS VSS VDD VDD sky130_fd_sc_hd__decap_3
XFILLER_54_246 VSS VSS VDD VDD sky130_fd_sc_hd__decap_3
XFILLER_54_279 VSS VSS VDD VDD sky130_fd_sc_hd__decap_3
XTAP_TAPCELL_ROW_52_436 VSS VDD sky130_fd_sc_hd__tapvpwrvgnd_1
XFILLER_6_309 VSS VSS VDD VDD sky130_fd_sc_hd__decap_3
XFILLER_7_6 VSS VSS VDD VDD sky130_fd_sc_hd__decap_3
XFILLER_45_213 VSS VSS VDD VDD sky130_fd_sc_hd__fill_1
XFILLER_45_268 VSS VSS VDD VDD sky130_fd_sc_hd__decap_3
XFILLER_13_110 VSS VSS VDD VDD sky130_fd_sc_hd__fill_2
XFILLER_42_72 VSS VSS VDD VDD sky130_fd_sc_hd__fill_2
X_1340_ net108 _0194_ net73 VSS VSS VDD VDD regs\[22\]\[2\] sky130_fd_sc_hd__dfrtp_1
XFILLER_36_224 VSS VSS VDD VDD sky130_fd_sc_hd__decap_3
XFILLER_3_33 VSS VSS VDD VDD sky130_fd_sc_hd__decap_3
XFILLER_3_66 VSS VSS VDD VDD sky130_fd_sc_hd__decap_3
XFILLER_3_88 VSS VSS VDD VDD sky130_fd_sc_hd__decap_3
X_1271_ net82 _0125_ net47 VSS VSS VDD VDD regs\[13\]\[5\] sky130_fd_sc_hd__dfrtp_1
XFILLER_51_205 VSS VSS VDD VDD sky130_fd_sc_hd__fill_1
X_0986_ regs\[13\]\[1\] net39 _0567_ VSS VSS VDD VDD _0121_ sky130_fd_sc_hd__mux2_1
Xfanout104 net107 VSS VSS VDD VDD net104 sky130_fd_sc_hd__buf_2
Xfanout115 net116 VSS VSS VDD VDD net115 sky130_fd_sc_hd__clkbuf_2
Xfanout126 net127 VSS VSS VDD VDD net126 sky130_fd_sc_hd__clkbuf_2
Xfanout137 net138 VSS VSS VDD VDD net137 sky130_fd_sc_hd__clkbuf_2
Xfanout148 net16 VSS VSS VDD VDD net148 sky130_fd_sc_hd__buf_4
Xfanout159 net14 VSS VSS VDD VDD net159 sky130_fd_sc_hd__buf_1
XFILLER_27_246 VSS VSS VDD VDD sky130_fd_sc_hd__decap_3
XFILLER_27_268 VSS VSS VDD VDD sky130_fd_sc_hd__decap_3
XFILLER_47_39 VSS VSS VDD VDD sky130_fd_sc_hd__decap_3
XFILLER_10_157 VSS VSS VDD VDD sky130_fd_sc_hd__decap_3
XFILLER_42_238 VSS VSS VDD VDD sky130_fd_sc_hd__decap_3
XFILLER_12_64 VSS VSS VDD VDD sky130_fd_sc_hd__decap_3
XFILLER_5_3 VSS VSS VDD VDD sky130_fd_sc_hd__decap_3
XFILLER_6_128 VSS VSS VDD VDD sky130_fd_sc_hd__decap_3
XFILLER_41_260 VSS VSS VDD VDD sky130_fd_sc_hd__decap_3
XFILLER_53_60 VSS VSS VDD VDD sky130_fd_sc_hd__decap_3
X_0840_ regs\[6\]\[7\] _0297_ _0324_ regs\[19\]\[7\] VSS VSS VDD VDD _0528_ sky130_fd_sc_hd__a22o_1
X_0771_ _0459_ _0460_ _0461_ VSS VSS VDD VDD _0462_ sky130_fd_sc_hd__or3_1
XFILLER_38_3 VSS VSS VDD VDD sky130_fd_sc_hd__decap_3
XFILLER_5_172 VSS VSS VDD VDD sky130_fd_sc_hd__fill_1
X_1323_ net112 _0177_ net77 VSS VSS VDD VDD regs\[20\]\[1\] sky130_fd_sc_hd__dfrtp_1
X_1254_ net98 _0108_ net63 VSS VSS VDD VDD regs\[11\]\[4\] sky130_fd_sc_hd__dfrtp_1
X_1185_ net86 _0039_ net51 VSS VSS VDD VDD regs\[2\]\[7\] sky130_fd_sc_hd__dfrtp_1
XTAP_TAPCELL_ROW_19_241 VSS VDD sky130_fd_sc_hd__tapvpwrvgnd_1
XFILLER_32_282 VSS VSS VDD VDD sky130_fd_sc_hd__decap_3
XPHY_EDGE_ROW_49_Left_107 VSS VSS VDD VDD sky130_fd_sc_hd__decap_3
X_0969_ regs\[11\]\[2\] net173 _0565_ VSS VSS VDD VDD _0106_ sky130_fd_sc_hd__mux2_1
XFILLER_55_330 VSS VSS VDD VDD sky130_fd_sc_hd__decap_3
XFILLER_23_30 VSS VSS VDD VDD sky130_fd_sc_hd__decap_3
XTAP_TAPCELL_ROW_25_277 VSS VDD sky130_fd_sc_hd__tapvpwrvgnd_1
XFILLER_2_153 VSS VSS VDD VDD sky130_fd_sc_hd__decap_3
XFILLER_0_12 VSS VSS VDD VDD sky130_fd_sc_hd__decap_3
XFILLER_0_78 VSS VSS VDD VDD sky130_fd_sc_hd__decap_3
XFILLER_24_9 VSS VSS VDD VDD sky130_fd_sc_hd__decap_3
XFILLER_38_319 VSS VSS VDD VDD sky130_fd_sc_hd__decap_3
XFILLER_48_71 VSS VSS VDD VDD sky130_fd_sc_hd__decap_3
XFILLER_14_293 VSS VSS VDD VDD sky130_fd_sc_hd__decap_3
XFILLER_21_208 VSS VSS VDD VDD sky130_fd_sc_hd__decap_3
XTAP_TAPCELL_ROW_16_222 VSS VDD sky130_fd_sc_hd__tapvpwrvgnd_1
XFILLER_9_54 VSS VSS VDD VDD sky130_fd_sc_hd__fill_2
XFILLER_9_21 VSS VSS VDD VDD sky130_fd_sc_hd__decap_3
X_0823_ regs\[19\]\[6\] _0324_ _0338_ regs\[10\]\[6\] VSS VSS VDD VDD _0512_ sky130_fd_sc_hd__a22o_1
X_0754_ net125 regs\[28\]\[4\] net36 VSS VSS VDD VDD _0445_ sky130_fd_sc_hd__and3_1
X_0685_ net133 regs\[20\]\[2\] net28 VSS VSS VDD VDD _0378_ sky130_fd_sc_hd__and3_1
XFILLER_29_308 VSS VSS VDD VDD sky130_fd_sc_hd__decap_3
XFILLER_56_127 VSS VSS VDD VDD sky130_fd_sc_hd__decap_3
X_1306_ net110 _0160_ net75 VSS VSS VDD VDD regs\[18\]\[0\] sky130_fd_sc_hd__dfrtp_1
XFILLER_37_341 VSS VSS VDD VDD sky130_fd_sc_hd__decap_3
XFILLER_44_18 VSS VSS VDD VDD sky130_fd_sc_hd__decap_3
XFILLER_44_29 VSS VSS VDD VDD sky130_fd_sc_hd__decap_3
X_1237_ net86 _0091_ net51 VSS VSS VDD VDD regs\[9\]\[3\] sky130_fd_sc_hd__dfrtp_1
X_1168_ net94 _0022_ net59 VSS VSS VDD VDD regs\[0\]\[6\] sky130_fd_sc_hd__dfrtp_1
X_1099_ regs\[25\]\[6\] net156 _0270_ VSS VSS VDD VDD _0222_ sky130_fd_sc_hd__mux2_1
XTAP_TAPCELL_ROW_39_358 VSS VDD sky130_fd_sc_hd__tapvpwrvgnd_1
XFILLER_20_274 VSS VSS VDD VDD sky130_fd_sc_hd__decap_3
XTAP_TAPCELL_ROW_22_258 VSS VDD sky130_fd_sc_hd__tapvpwrvgnd_1
XFILLER_18_41 VSS VSS VDD VDD sky130_fd_sc_hd__decap_3
XFILLER_18_74 VSS VSS VDD VDD sky130_fd_sc_hd__decap_3
XFILLER_47_116 VSS VSS VDD VDD sky130_fd_sc_hd__decap_3
XFILLER_34_95 VSS VSS VDD VDD sky130_fd_sc_hd__fill_2
XTAP_TAPCELL_ROW_13_203 VSS VDD sky130_fd_sc_hd__tapvpwrvgnd_1
XFILLER_11_296 VSS VSS VDD VDD sky130_fd_sc_hd__decap_3
XFILLER_50_50 VSS VSS VDD VDD sky130_fd_sc_hd__decap_3
XFILLER_50_83 VSS VSS VDD VDD sky130_fd_sc_hd__fill_1
XFILLER_50_94 VSS VSS VDD VDD sky130_fd_sc_hd__fill_2
XFILLER_7_212 VSS VSS VDD VDD sky130_fd_sc_hd__decap_3
XFILLER_7_267 VSS VSS VDD VDD sky130_fd_sc_hd__decap_3
XFILLER_22_6 VSS VSS VDD VDD sky130_fd_sc_hd__decap_3
XFILLER_34_300 VSS VSS VDD VDD sky130_fd_sc_hd__decap_3
X_1022_ regs\[17\]\[1\] net40 _0571_ VSS VSS VDD VDD _0153_ sky130_fd_sc_hd__mux2_1
XTAP_TAPCELL_ROW_36_339 VSS VDD sky130_fd_sc_hd__tapvpwrvgnd_1
XFILLER_39_18 VSS VSS VDD VDD sky130_fd_sc_hd__decap_3
X_0806_ net145 net22 _0494_ _0495_ VSS VSS VDD VDD _0013_ sky130_fd_sc_hd__a22o_1
X_0737_ net129 regs\[15\]\[3\] net38 VSS VSS VDD VDD _0429_ sky130_fd_sc_hd__and3b_1
X_0668_ net126 regs\[28\]\[1\] net36 VSS VSS VDD VDD _0362_ sky130_fd_sc_hd__and3_1
XFILLER_55_39 VSS VSS VDD VDD sky130_fd_sc_hd__decap_3
X_0599_ net124 _0293_ VSS VSS VDD VDD _0294_ sky130_fd_sc_hd__and2b_2
XFILLER_4_226 VSS VSS VDD VDD sky130_fd_sc_hd__decap_3
XFILLER_28_160 VSS VSS VDD VDD sky130_fd_sc_hd__decap_3
XFILLER_29_84 VSS VSS VDD VDD sky130_fd_sc_hd__decap_3
XFILLER_45_83 VSS VSS VDD VDD sky130_fd_sc_hd__decap_3
XANTENNA_4 _0391_ VSS VSS VDD VDD sky130_fd_sc_hd__diode_2
XFILLER_3_281 VSS VSS VDD VDD sky130_fd_sc_hd__fill_2
XFILLER_6_44 VSS VSS VDD VDD sky130_fd_sc_hd__decap_3
XFILLER_20_3 VSS VSS VDD VDD sky130_fd_sc_hd__decap_3
XTAP_TAPCELL_ROW_49_420 VSS VDD sky130_fd_sc_hd__tapvpwrvgnd_1
XFILLER_19_193 VSS VSS VDD VDD sky130_fd_sc_hd__decap_3
XFILLER_22_303 VSS VSS VDD VDD sky130_fd_sc_hd__decap_3
XFILLER_34_130 VSS VSS VDD VDD sky130_fd_sc_hd__decap_3
XFILLER_34_141 VSS VSS VDD VDD sky130_fd_sc_hd__decap_3
X_1005_ regs\[15\]\[2\] net173 _0569_ VSS VSS VDD VDD _0138_ sky130_fd_sc_hd__mux2_1
XFILLER_57_299 VSS VSS VDD VDD sky130_fd_sc_hd__decap_3
XTAP_TAPCELL_ROW_55_456 VSS VDD sky130_fd_sc_hd__tapvpwrvgnd_1
XFILLER_13_314 VSS VSS VDD VDD sky130_fd_sc_hd__decap_3
XFILLER_15_42 VSS VSS VDD VDD sky130_fd_sc_hd__decap_3
XFILLER_40_133 VSS VSS VDD VDD sky130_fd_sc_hd__decap_3
XFILLER_40_144 VSS VSS VDD VDD sky130_fd_sc_hd__fill_2
XFILLER_40_155 VSS VSS VDD VDD sky130_fd_sc_hd__decap_3
XFILLER_40_177 VSS VSS VDD VDD sky130_fd_sc_hd__fill_1
XFILLER_31_30 VSS VSS VDD VDD sky130_fd_sc_hd__decap_3
XFILLER_0_240 VSS VSS VDD VDD sky130_fd_sc_hd__fill_1
XFILLER_0_262 VSS VSS VDD VDD sky130_fd_sc_hd__fill_1
XFILLER_0_284 VSS VSS VDD VDD sky130_fd_sc_hd__decap_3
XFILLER_48_277 VSS VSS VDD VDD sky130_fd_sc_hd__decap_3
XFILLER_16_141 VSS VSS VDD VDD sky130_fd_sc_hd__fill_2
XFILLER_31_111 VSS VSS VDD VDD sky130_fd_sc_hd__fill_1
XFILLER_56_71 VSS VSS VDD VDD sky130_fd_sc_hd__decap_3
XTAP_TAPCELL_ROW_46_401 VSS VDD sky130_fd_sc_hd__tapvpwrvgnd_1
XFILLER_31_155 VSS VSS VDD VDD sky130_fd_sc_hd__decap_3
.ends
