* NGSPICE file created from chip_io.ext - technology: sky130A

.subckt sky130_fd_io__com_ctl_ls_octl VCC_IO VPB OUT_H_N OUT_H IN RST_H SET_H HLD_H_N
+ a_992_934# a_181_1305# a_n17_1379#
X0 a_361_1391# a_181_1305# a_128_1391# a_n17_1379# sky130_fd_pr__nfet_05v0_nvt ad=0.14 pd=1.28 as=0.265 ps=2.53 w=1 l=0.9
X1 VCC_IO a_130_181# OUT_H VCC_IO sky130_fd_pr__pfet_g5v0d10v5 ad=0.42 pd=3.28 as=0.795 ps=6.53 w=3 l=0.6
X2 a_128_1391# a_181_1305# a_361_1391# a_n17_1379# sky130_fd_pr__nfet_05v0_nvt ad=0.265 pd=2.53 as=0.14 ps=1.28 w=1 l=0.9
X3 a_n17_1379# a_634_829# a_128_1391# a_n17_1379# sky130_fd_pr__nfet_01v8_lvt ad=0.14 pd=1.28 as=0.14 ps=1.28 w=1 l=0.15
X4 a_128_1391# a_634_829# a_n17_1379# a_n17_1379# sky130_fd_pr__nfet_01v8_lvt ad=0.14 pd=1.28 as=0.28 ps=2.56 w=1 l=0.15
X5 a_361_1391# HLD_H_N a_130_181# a_n17_1379# sky130_fd_pr__nfet_g5v0d10v5 ad=0.795 pd=6.53 as=0.795 ps=6.53 w=3 l=0.6
X6 a_634_829# a_992_934# a_181_1305# VPB sky130_fd_pr__pfet_01v8_hvt ad=0.265 pd=2.53 as=0.14 ps=1.28 w=1 l=0.25
X7 a_361_1391# a_181_1305# a_128_1391# a_n17_1379# sky130_fd_pr__nfet_05v0_nvt ad=0.14 pd=1.28 as=0.265 ps=2.53 w=1 l=0.9
X8 a_n17_1379# a_634_829# a_128_1391# a_n17_1379# sky130_fd_pr__nfet_01v8_lvt ad=0.14 pd=1.28 as=0.14 ps=1.28 w=1 l=0.15
X9 OUT_H_N a_65_861# VCC_IO VCC_IO sky130_fd_pr__pfet_g5v0d10v5 ad=0.795 pd=6.53 as=0.42 ps=3.28 w=3 l=0.6
X10 a_n17_1379# a_992_934# a_724_1391# a_n17_1379# sky130_fd_pr__nfet_01v8_lvt ad=0.14 pd=1.28 as=0.14 ps=1.28 w=1 l=0.15
X11 a_128_1391# a_634_829# a_n17_1379# a_n17_1379# sky130_fd_pr__nfet_01v8_lvt ad=0.14 pd=1.28 as=0.14 ps=1.28 w=1 l=0.15
X12 a_724_1391# a_992_934# a_n17_1379# a_n17_1379# sky130_fd_pr__nfet_01v8_lvt ad=0.14 pd=1.28 as=0.14 ps=1.28 w=1 l=0.15
X13 a_65_861# HLD_H_N a_957_1391# a_n17_1379# sky130_fd_pr__nfet_g5v0d10v5 ad=0.42 pd=3.28 as=0.795 ps=6.53 w=3 l=0.6
X14 OUT_H a_130_181# a_n17_1379# a_n17_1379# sky130_fd_pr__nfet_g5v0d10v5 ad=0.28 pd=2.56 as=0.14 ps=1.28 w=1 l=0.6
X15 a_n17_1379# a_992_934# a_724_1391# a_n17_1379# sky130_fd_pr__nfet_01v8_lvt ad=0.265 pd=2.53 as=0.14 ps=1.28 w=1 l=0.15
X16 a_65_861# a_130_181# VCC_IO VCC_IO sky130_fd_pr__pfet_g5v0d10v5 ad=0.19875 pd=2.03 as=0.19875 ps=2.03 w=0.75 l=0.5
X17 a_n17_1379# a_65_861# a_130_181# a_n17_1379# sky130_fd_pr__nfet_g5v0d10v5 ad=0.105 pd=1.03 as=0.19875 ps=2.03 w=0.75 l=1
X18 a_724_1391# a_992_934# a_n17_1379# a_n17_1379# sky130_fd_pr__nfet_01v8_lvt ad=0.14 pd=1.28 as=0.14 ps=1.28 w=1 l=0.15
X19 a_181_1305# IN a_992_934# VPB sky130_fd_pr__pfet_01v8_hvt ad=0.14 pd=1.28 as=0.265 ps=2.53 w=1 l=0.25
X20 a_957_1391# a_181_1305# a_724_1391# a_n17_1379# sky130_fd_pr__nfet_05v0_nvt ad=0.14 pd=1.28 as=0.265 ps=2.53 w=1 l=0.9
X21 a_n17_1379# a_65_861# OUT_H_N a_n17_1379# sky130_fd_pr__nfet_g5v0d10v5 ad=0.14 pd=1.28 as=0.28 ps=2.56 w=1 l=0.6
X22 a_130_181# a_65_861# VCC_IO VCC_IO sky130_fd_pr__pfet_g5v0d10v5 ad=0.19875 pd=2.03 as=0.19875 ps=2.03 w=0.75 l=0.5
X23 a_n17_1379# IN a_992_934# a_n17_1379# sky130_fd_pr__nfet_01v8 ad=0.14 pd=1.28 as=0.28 ps=2.56 w=1 l=0.25
X24 a_724_1391# a_181_1305# a_957_1391# a_n17_1379# sky130_fd_pr__nfet_05v0_nvt ad=0.265 pd=2.53 as=0.14 ps=1.28 w=1 l=0.9
X25 a_65_861# a_130_181# a_n17_1379# a_n17_1379# sky130_fd_pr__nfet_g5v0d10v5 ad=0.19875 pd=2.03 as=0.105 ps=1.03 w=0.75 l=1
X26 a_957_1391# a_181_1305# a_724_1391# a_n17_1379# sky130_fd_pr__nfet_05v0_nvt ad=0.14 pd=1.28 as=0.265 ps=2.53 w=1 l=0.9
X27 a_634_829# a_992_934# a_n17_1379# a_n17_1379# sky130_fd_pr__nfet_01v8 ad=0.28 pd=2.56 as=0.14 ps=1.28 w=1 l=0.25
X28 a_130_181# SET_H a_n17_1379# a_n17_1379# sky130_fd_pr__nfet_g5v0d10v5 ad=0.795 pd=6.53 as=0.42 ps=3.28 w=3 l=0.6
X29 a_724_1391# a_181_1305# a_957_1391# a_n17_1379# sky130_fd_pr__nfet_05v0_nvt ad=0.265 pd=2.53 as=0.14 ps=1.28 w=1 l=0.9
X30 a_128_1391# a_181_1305# a_361_1391# a_n17_1379# sky130_fd_pr__nfet_05v0_nvt ad=0.265 pd=2.53 as=0.14 ps=1.28 w=1 l=0.9
X31 a_n17_1379# RST_H a_65_861# a_n17_1379# sky130_fd_pr__nfet_g5v0d10v5 ad=0.42 pd=3.28 as=0.42 ps=3.28 w=3 l=0.6
.ends

.subckt sky130_fd_io__gpiov2_octl PDEN_H_N[1] PDEN_H_N[0] SLOW SLOW_H VCC_IO DM_H[1]
+ DM_H[0] DM_H[2] DM_H_N[0] DM_H_N[1] DM_H_N[2] PUEN_2OR1_H a_n8755_2384# a_n9051_2020#
+ w_n9346_2317# a_n9227_2020# a_n9283_2046# a_5840_3586# m1_n8913_3102# VPWR a_n8875_2020#
+ a_4338_3622# a_3924_6676# a_n8931_2384# a_4514_3388# SLOW_H_N VGND a_5813_4576#
+ HLD_I_H_N OD_H
Xsky130_fd_io__com_ctl_ls_octl_0 VCC_IO VPWR SLOW_H_N SLOW_H SLOW OD_H VGND HLD_I_H_N
+ m2_5755_2254# VPWR VGND sky130_fd_io__com_ctl_ls_octl
X0 a_n8755_2384# a_n9280_2384# a_n8755_2046# VGND sky130_fd_pr__nfet_g5v0d10v5 ad=0.1855 pd=1.93 as=0.098 ps=0.98 w=0.7 l=0.6
X1 a_n9107_2384# a_n9227_2020# a_n9280_2384# w_n9346_2317# sky130_fd_pr__pfet_g5v0d10v5 ad=0.14 pd=1.28 as=0.265 ps=2.53 w=1 l=0.6
X2 VCC_IO DM_H_N[0] a_4520_6066# VCC_IO sky130_fd_pr__pfet_g5v0d10v5 ad=0.265 pd=2.53 as=0.14 ps=1.28 w=1 l=0.6
X3 a_3871_7368# a_3924_6676# VCC_IO VCC_IO sky130_fd_pr__pfet_g5v0d10v5 ad=0.14 pd=1.28 as=0.265 ps=2.53 w=1 l=0.6
X4 a_4634_3414# a_4514_3388# a_4458_3414# VGND sky130_fd_pr__nfet_g5v0d10v5 ad=0.098 pd=0.98 as=0.098 ps=0.98 w=0.7 l=0.6
X5 a_4872_6702# DM_H_N[2] VCC_IO VCC_IO sky130_fd_pr__pfet_g5v0d10v5 ad=0.14 pd=1.28 as=0.14 ps=1.28 w=1 l=0.6
X6 VCC_IO DM_H[2] a_3966_4619# VCC_IO sky130_fd_pr__pfet_g5v0d10v5 ad=0.14 pd=1.28 as=0.265 ps=2.53 w=1 l=0.6
X7 a_4996_5728# a_4520_6066# PUEN_2OR1_H VGND sky130_fd_pr__nfet_g5v0d10v5 ad=0.098 pd=0.98 as=0.1855 ps=1.93 w=0.7 l=0.6
X8 VCC_IO a_4347_7368# a_5651_5728# VCC_IO sky130_fd_pr__pfet_g5v0d10v5 ad=0.14 pd=1.28 as=0.265 ps=2.53 w=1 l=0.6
X9 a_5813_4576# a_5693_4550# VCC_IO VCC_IO sky130_fd_pr__pfet_g5v0d10v5 ad=0.14 pd=1.28 as=0.265 ps=2.53 w=1 l=0.6
X10 VCC_IO a_5052_5702# PUEN_2OR1_H VCC_IO sky130_fd_pr__pfet_g5v0d10v5 ad=0.14 pd=1.28 as=0.14 ps=1.28 w=1 l=0.6
X11 a_5488_3924# DM_H_N[1] a_5315_3924# VCC_IO sky130_fd_pr__pfet_g5v0d10v5 ad=0.14 pd=1.28 as=0.265 ps=2.53 w=1 l=0.6
X12 VCC_IO a_5720_3560# a_5840_3586# VCC_IO sky130_fd_pr__pfet_g5v0d10v5 ad=0.14 pd=1.28 as=0.14 ps=1.28 w=1 l=0.6
X13 VCC_IO DM_H[0] a_5052_5702# VCC_IO sky130_fd_pr__pfet_g5v0d10v5 ad=0.265 pd=2.53 as=0.14 ps=1.28 w=1 l=0.6
X14 a_4282_3816# DM_H[2] VCC_IO VCC_IO sky130_fd_pr__pfet_g5v0d10v5 ad=0.14 pd=1.28 as=0.14 ps=1.28 w=1 l=0.6
X15 VCC_IO DM_H_N[0] a_5175_7368# VCC_IO sky130_fd_pr__pfet_g5v0d10v5 ad=0.265 pd=2.53 as=0.14 ps=1.28 w=1 l=0.6
X16 a_4634_3816# a_3933_3414# a_4458_3414# VCC_IO sky130_fd_pr__pfet_g5v0d10v5 ad=0.14 pd=1.28 as=0.14 ps=1.28 w=1 l=0.6
X17 a_4491_4619# a_4371_4587# a_4315_4619# VCC_IO sky130_fd_pr__pfet_g5v0d10v5 ad=0.14 pd=1.28 as=0.14 ps=1.28 w=1 l=0.6
X18 PDEN_H_N[1] a_5651_6702# VGND VGND sky130_fd_pr__nfet_g5v0d10v5 ad=0.098 pd=0.98 as=0.098 ps=0.98 w=0.7 l=0.6
X19 a_5315_3924# DM_H_N[1] VGND VGND sky130_fd_pr__nfet_g5v0d10v5 ad=0.098 pd=0.98 as=0.196 ps=1.96 w=0.7 l=0.6
X20 a_5513_4576# a_3871_7368# VCC_IO VCC_IO sky130_fd_pr__pfet_g5v0d10v5 ad=0.265 pd=2.53 as=0.265 ps=2.53 w=1 l=0.6
X21 VCC_IO DM_H[1] a_4667_4619# VCC_IO sky130_fd_pr__pfet_g5v0d10v5 ad=0.14 pd=1.28 as=0.14 ps=1.28 w=1 l=0.6
X22 a_4044_6066# DM_H_N[1] a_3871_6066# VCC_IO sky130_fd_pr__pfet_g5v0d10v5 ad=0.14 pd=1.28 as=0.265 ps=2.53 w=1 l=0.6
X23 a_n8931_2384# a_n9051_2020# a_n9107_2384# w_n9346_2317# sky130_fd_pr__pfet_g5v0d10v5 ad=0.14 pd=1.28 as=0.14 ps=1.28 w=1 l=0.6
X24 a_n8755_2046# a_n8875_2020# a_n9283_2046# VGND sky130_fd_pr__nfet_g5v0d10v5 ad=0.098 pd=0.98 as=0.098 ps=0.98 w=0.7 l=0.6
X25 PDEN_H_N[0] a_5651_5728# VGND VGND sky130_fd_pr__nfet_g5v0d10v5 ad=0.098 pd=0.98 as=0.098 ps=0.98 w=0.7 l=0.6
X26 a_4520_6066# a_3871_6066# VCC_IO VCC_IO sky130_fd_pr__pfet_g5v0d10v5 ad=0.14 pd=1.28 as=0.265 ps=2.53 w=1 l=0.6
X27 a_4347_7368# DM_H[0] VCC_IO VCC_IO sky130_fd_pr__pfet_g5v0d10v5 ad=0.14 pd=1.28 as=0.265 ps=2.53 w=1 l=0.6
X28 a_n8931_2384# a_n9280_2384# a_n8755_2384# w_n9346_2317# sky130_fd_pr__pfet_g5v0d10v5 ad=0.265 pd=2.53 as=0.14 ps=1.28 w=1 l=0.6
X29 VCC_IO a_4458_3414# a_5488_3924# VCC_IO sky130_fd_pr__pfet_g5v0d10v5 ad=0.14 pd=1.28 as=0.14 ps=1.28 w=1 l=0.6
X30 a_5513_4576# a_3871_7368# VGND VGND sky130_fd_pr__nfet_g5v0d10v5 ad=0.1855 pd=1.93 as=0.1855 ps=1.93 w=0.7 l=0.6
X31 a_4371_4587# DM_H[1] VCC_IO VCC_IO sky130_fd_pr__pfet_g5v0d10v5 ad=0.265 pd=2.53 as=0.14 ps=1.28 w=1 l=0.6
X32 VGND a_4458_3414# a_5315_3924# VGND sky130_fd_pr__nfet_g5v0d10v5 ad=0.098 pd=0.98 as=0.098 ps=0.98 w=0.7 l=0.6
X33 VCC_IO a_5693_4550# a_5813_4576# VCC_IO sky130_fd_pr__pfet_g5v0d10v5 ad=0.14 pd=1.28 as=0.14 ps=1.28 w=1 l=0.6
X34 a_4338_3622# DM_H[0] VGND VGND sky130_fd_pr__nfet_g5v0d10v5 ad=0.1855 pd=1.93 as=0.098 ps=0.98 w=0.7 l=0.6
X35 PUEN_2OR1_H a_4520_6066# VCC_IO VCC_IO sky130_fd_pr__pfet_g5v0d10v5 ad=0.14 pd=1.28 as=0.265 ps=2.53 w=1 l=0.6
X36 VGND PUEN_2OR1_H a_4044_7368# VGND sky130_fd_pr__nfet_g5v0d10v5 ad=0.1855 pd=1.93 as=0.098 ps=0.98 w=0.7 l=0.6
X37 PDEN_H_N[1] a_5651_6702# VCC_IO VCC_IO sky130_fd_pr__pfet_g5v0d10v5 ad=0.14 pd=1.28 as=0.14 ps=1.28 w=1 l=0.6
X38 a_5348_7368# a_4872_6702# a_5175_7368# VGND sky130_fd_pr__nfet_g5v0d10v5 ad=0.098 pd=0.98 as=0.1855 ps=1.93 w=0.7 l=0.6
X39 VCC_IO DM_H_N[0] a_4520_6066# VCC_IO sky130_fd_pr__pfet_g5v0d10v5 ad=0.265 pd=2.53 as=0.14 ps=1.28 w=1 l=0.6
X40 VGND a_5651_6702# PDEN_H_N[1] VGND sky130_fd_pr__nfet_g5v0d10v5 ad=0.1855 pd=1.93 as=0.098 ps=0.98 w=0.7 l=0.6
X41 VCC_IO DM_H[1] a_4347_7368# VCC_IO sky130_fd_pr__pfet_g5v0d10v5 ad=0.14 pd=1.28 as=0.14 ps=1.28 w=1 l=0.6
X42 a_5840_3586# a_5720_3560# VCC_IO VCC_IO sky130_fd_pr__pfet_g5v0d10v5 ad=0.14 pd=1.28 as=0.14 ps=1.28 w=1 l=0.6
X43 VCC_IO DM_H_N[1] a_4872_6702# VCC_IO sky130_fd_pr__pfet_g5v0d10v5 ad=0.265 pd=2.53 as=0.14 ps=1.28 w=1 l=0.6
X44 a_n8755_2384# a_n8875_2020# a_n8931_2384# w_n9346_2317# sky130_fd_pr__pfet_g5v0d10v5 ad=0.14 pd=1.28 as=0.14 ps=1.28 w=1 l=0.6
X45 VCC_IO a_4347_7368# a_5651_5728# VCC_IO sky130_fd_pr__pfet_g5v0d10v5 ad=0.14 pd=1.28 as=0.265 ps=2.53 w=1 l=0.6
X46 a_4458_3414# a_4338_3622# a_4282_3816# VCC_IO sky130_fd_pr__pfet_g5v0d10v5 ad=0.14 pd=1.28 as=0.14 ps=1.28 w=1 l=0.6
X47 a_4338_3622# DM_H[0] VCC_IO VCC_IO sky130_fd_pr__pfet_g5v0d10v5 ad=0.265 pd=2.53 as=0.14 ps=1.28 w=1 l=0.6
X48 a_4315_5349# DM_H[2] VGND VGND sky130_fd_pr__nfet_g5v0d10v5 ad=0.098 pd=0.98 as=0.098 ps=0.98 w=0.7 l=0.6
X49 VCC_IO a_5175_7368# a_5651_6702# VCC_IO sky130_fd_pr__pfet_g5v0d10v5 ad=0.14 pd=1.28 as=0.265 ps=2.53 w=1 l=0.6
X50 a_4667_5349# a_4371_4587# a_4491_4619# VGND sky130_fd_pr__nfet_g5v0d10v5 ad=0.098 pd=0.98 as=0.098 ps=0.98 w=0.7 l=0.6
X51 VGND DM_H_N[2] a_3871_6066# VGND sky130_fd_pr__nfet_g5v0d10v5 ad=0.1855 pd=1.93 as=0.098 ps=0.98 w=0.7 l=0.6
X52 VGND a_5693_4550# a_5813_4576# VGND sky130_fd_pr__nfet_g5v0d10v5 ad=0.098 pd=0.98 as=0.098 ps=0.98 w=0.7 l=0.6
X53 a_5840_3586# a_5720_3560# VGND VGND sky130_fd_pr__nfet_g5v0d10v5 ad=0.098 pd=0.98 as=0.098 ps=0.98 w=0.7 l=0.6
X54 a_5813_4576# a_5693_4550# VCC_IO VCC_IO sky130_fd_pr__pfet_g5v0d10v5 ad=0.14 pd=1.28 as=0.265 ps=2.53 w=1 l=0.6
X55 a_5348_5728# a_4491_4619# VGND VGND sky130_fd_pr__nfet_g5v0d10v5 ad=0.098 pd=0.98 as=0.098 ps=0.98 w=0.7 l=0.6
X56 VGND a_5651_5728# PDEN_H_N[0] VGND sky130_fd_pr__nfet_g5v0d10v5 ad=0.1855 pd=1.93 as=0.098 ps=0.98 w=0.7 l=0.6
X57 VGND a_3933_3414# a_4634_3414# VGND sky130_fd_pr__nfet_g5v0d10v5 ad=0.098 pd=0.98 as=0.098 ps=0.98 w=0.7 l=0.6
X58 a_4315_4619# DM_H[2] VCC_IO VCC_IO sky130_fd_pr__pfet_g5v0d10v5 ad=0.14 pd=1.28 as=0.14 ps=1.28 w=1 l=0.6
X59 a_5693_4550# a_5513_4576# VCC_IO VCC_IO sky130_fd_pr__pfet_g5v0d10v5 ad=0.265 pd=2.53 as=0.14 ps=1.28 w=1 l=0.6
X60 a_4667_4619# a_3966_4619# a_4491_4619# VCC_IO sky130_fd_pr__pfet_g5v0d10v5 ad=0.14 pd=1.28 as=0.14 ps=1.28 w=1 l=0.6
X61 PDEN_H_N[0] a_5651_5728# VCC_IO VCC_IO sky130_fd_pr__pfet_g5v0d10v5 ad=0.14 pd=1.28 as=0.14 ps=1.28 w=1 l=0.6
X62 a_4044_6066# DM_H_N[1] a_3871_6066# VCC_IO sky130_fd_pr__pfet_g5v0d10v5 ad=0.14 pd=1.28 as=0.265 ps=2.53 w=1 l=0.6
X63 VGND DM_H_N[0] a_5348_7368# VGND sky130_fd_pr__nfet_g5v0d10v5 ad=0.1855 pd=1.93 as=0.098 ps=0.98 w=0.7 l=0.6
X64 a_3871_7368# a_3924_6676# VCC_IO VCC_IO sky130_fd_pr__pfet_g5v0d10v5 ad=0.14 pd=1.28 as=0.265 ps=2.53 w=1 l=0.6
X65 a_4872_6702# DM_H_N[2] VCC_IO VCC_IO sky130_fd_pr__pfet_g5v0d10v5 ad=0.14 pd=1.28 as=0.14 ps=1.28 w=1 l=0.6
X66 VCC_IO a_5720_3560# a_5840_3586# VCC_IO sky130_fd_pr__pfet_g5v0d10v5 ad=0.14 pd=1.28 as=0.14 ps=1.28 w=1 l=0.6
X67 a_4282_3816# DM_H[2] VCC_IO VCC_IO sky130_fd_pr__pfet_g5v0d10v5 ad=0.14 pd=1.28 as=0.14 ps=1.28 w=1 l=0.6
X68 VCC_IO DM_H[0] a_4634_3816# VCC_IO sky130_fd_pr__pfet_g5v0d10v5 ad=0.14 pd=1.28 as=0.14 ps=1.28 w=1 l=0.6
X69 VCC_IO PUEN_2OR1_H a_3871_7368# VCC_IO sky130_fd_pr__pfet_g5v0d10v5 ad=0.265 pd=2.53 as=0.14 ps=1.28 w=1 l=0.6
X70 a_4634_3816# a_3933_3414# a_4458_3414# VCC_IO sky130_fd_pr__pfet_g5v0d10v5 ad=0.14 pd=1.28 as=0.14 ps=1.28 w=1 l=0.6
X71 a_5813_4576# a_5693_4550# VGND VGND sky130_fd_pr__nfet_g5v0d10v5 ad=0.098 pd=0.98 as=0.1855 ps=1.93 w=0.7 l=0.6
X72 a_4491_4619# DM_H[1] a_4315_5349# VGND sky130_fd_pr__nfet_g5v0d10v5 ad=0.098 pd=0.98 as=0.098 ps=0.98 w=0.7 l=0.6
X73 a_n9280_2384# a_n9227_2020# a_n9283_2046# VGND sky130_fd_pr__nfet_g5v0d10v5 ad=0.098 pd=0.98 as=0.196 ps=1.96 w=0.7 l=0.6
X74 VGND a_3966_4619# a_4667_5349# VGND sky130_fd_pr__nfet_g5v0d10v5 ad=0.098 pd=0.98 as=0.098 ps=0.98 w=0.7 l=0.6
X75 a_5175_7368# a_4872_6702# VCC_IO VCC_IO sky130_fd_pr__pfet_g5v0d10v5 ad=0.14 pd=1.28 as=0.265 ps=2.53 w=1 l=0.6
X76 VGND a_5720_3560# a_5840_3586# VGND sky130_fd_pr__nfet_g5v0d10v5 ad=0.098 pd=0.98 as=0.098 ps=0.98 w=0.7 l=0.6
X77 VGND a_5052_5702# a_4996_5728# VGND sky130_fd_pr__nfet_g5v0d10v5 ad=0.098 pd=0.98 as=0.098 ps=0.98 w=0.7 l=0.6
X78 VCC_IO a_5651_6702# PDEN_H_N[1] VCC_IO sky130_fd_pr__pfet_g5v0d10v5 ad=0.265 pd=2.53 as=0.14 ps=1.28 w=1 l=0.6
X79 a_5052_5702# DM_H[0] a_5348_5728# VGND sky130_fd_pr__nfet_g5v0d10v5 ad=0.1855 pd=1.93 as=0.098 ps=0.98 w=0.7 l=0.6
X80 a_n8931_2384# a_n9280_2384# a_n8755_2384# w_n9346_2317# sky130_fd_pr__pfet_g5v0d10v5 ad=0.265 pd=2.53 as=0.14 ps=1.28 w=1 l=0.6
X81 VGND DM_H[2] a_3933_3414# VGND sky130_fd_pr__nfet_g5v0d10v5 ad=0.098 pd=0.98 as=0.1855 ps=1.93 w=0.7 l=0.6
X82 a_5720_3560# a_5315_3924# VCC_IO VCC_IO sky130_fd_pr__pfet_g5v0d10v5 ad=0.265 pd=2.53 as=0.14 ps=1.28 w=1 l=0.6
X83 a_4491_4619# a_4371_4587# a_4315_4619# VCC_IO sky130_fd_pr__pfet_g5v0d10v5 ad=0.14 pd=1.28 as=0.14 ps=1.28 w=1 l=0.6
X84 VCC_IO DM_H[1] a_4667_4619# VCC_IO sky130_fd_pr__pfet_g5v0d10v5 ad=0.14 pd=1.28 as=0.14 ps=1.28 w=1 l=0.6
X85 a_4520_7368# DM_H[0] a_4347_7368# VGND sky130_fd_pr__nfet_g5v0d10v5 ad=0.098 pd=0.98 as=0.1855 ps=1.93 w=0.7 l=0.6
X86 VCC_IO DM_H[2] a_3966_4619# VCC_IO sky130_fd_pr__pfet_g5v0d10v5 ad=0.14 pd=1.28 as=0.265 ps=2.53 w=1 l=0.6
X87 PUEN_2OR1_H a_4520_6066# VCC_IO VCC_IO sky130_fd_pr__pfet_g5v0d10v5 ad=0.14 pd=1.28 as=0.265 ps=2.53 w=1 l=0.6
X88 VCC_IO DM_H[2] a_3933_3414# VCC_IO sky130_fd_pr__pfet_g5v0d10v5 ad=0.14 pd=1.28 as=0.265 ps=2.53 w=1 l=0.6
X89 VCC_IO DM_H_N[2] a_4044_6066# VCC_IO sky130_fd_pr__pfet_g5v0d10v5 ad=0.265 pd=2.53 as=0.14 ps=1.28 w=1 l=0.6
X90 a_n9283_2046# a_n9051_2020# a_n9280_2384# VGND sky130_fd_pr__nfet_g5v0d10v5 ad=0.098 pd=0.98 as=0.098 ps=0.98 w=0.7 l=0.6
X91 a_4371_4587# DM_H[1] VGND VGND sky130_fd_pr__nfet_g5v0d10v5 ad=0.1855 pd=1.93 as=0.098 ps=0.98 w=0.7 l=0.6
X92 a_5052_5702# a_4491_4619# VCC_IO VCC_IO sky130_fd_pr__pfet_g5v0d10v5 ad=0.14 pd=1.28 as=0.14 ps=1.28 w=1 l=0.6
X93 a_4520_5728# a_3871_6066# VGND VGND sky130_fd_pr__nfet_g5v0d10v5 ad=0.098 pd=0.98 as=0.1855 ps=1.93 w=0.7 l=0.6
X94 VCC_IO DM_H_N[0] a_5175_7368# VCC_IO sky130_fd_pr__pfet_g5v0d10v5 ad=0.265 pd=2.53 as=0.14 ps=1.28 w=1 l=0.6
X95 VCC_IO a_5651_5728# PDEN_H_N[0] VCC_IO sky130_fd_pr__pfet_g5v0d10v5 ad=0.265 pd=2.53 as=0.14 ps=1.28 w=1 l=0.6
X96 a_n8755_2384# a_n8875_2020# a_n8931_2384# w_n9346_2317# sky130_fd_pr__pfet_g5v0d10v5 ad=0.14 pd=1.28 as=0.14 ps=1.28 w=1 l=0.6
X97 a_5488_3924# DM_H_N[1] a_5315_3924# VCC_IO sky130_fd_pr__pfet_g5v0d10v5 ad=0.14 pd=1.28 as=0.265 ps=2.53 w=1 l=0.6
X98 a_4371_4587# DM_H[1] VCC_IO VCC_IO sky130_fd_pr__pfet_g5v0d10v5 ad=0.265 pd=2.53 as=0.14 ps=1.28 w=1 l=0.6
X99 VGND DM_H[1] a_4520_7368# VGND sky130_fd_pr__nfet_g5v0d10v5 ad=0.098 pd=0.98 as=0.098 ps=0.98 w=0.7 l=0.6
X100 a_n9107_2384# a_n9227_2020# a_n9280_2384# w_n9346_2317# sky130_fd_pr__pfet_g5v0d10v5 ad=0.14 pd=1.28 as=0.265 ps=2.53 w=1 l=0.6
X101 a_4872_6702# DM_H_N[1] a_4872_7368# VGND sky130_fd_pr__nfet_g5v0d10v5 ad=0.1855 pd=1.93 as=0.098 ps=0.98 w=0.7 l=0.6
X102 VGND a_5175_7368# a_5651_6702# VGND sky130_fd_pr__nfet_g5v0d10v5 ad=0.098 pd=0.98 as=0.1855 ps=1.93 w=0.7 l=0.6
X103 a_5693_4550# a_5513_4576# VCC_IO VCC_IO sky130_fd_pr__pfet_g5v0d10v5 ad=0.265 pd=2.53 as=0.14 ps=1.28 w=1 l=0.6
X104 PDEN_H_N[0] a_5651_5728# VCC_IO VCC_IO sky130_fd_pr__pfet_g5v0d10v5 ad=0.14 pd=1.28 as=0.14 ps=1.28 w=1 l=0.6
X105 PDEN_H_N[1] a_5651_6702# VCC_IO VCC_IO sky130_fd_pr__pfet_g5v0d10v5 ad=0.14 pd=1.28 as=0.14 ps=1.28 w=1 l=0.6
X106 a_4338_3622# DM_H[0] VCC_IO VCC_IO sky130_fd_pr__pfet_g5v0d10v5 ad=0.265 pd=2.53 as=0.14 ps=1.28 w=1 l=0.6
X107 VCC_IO a_5052_5702# PUEN_2OR1_H VCC_IO sky130_fd_pr__pfet_g5v0d10v5 ad=0.14 pd=1.28 as=0.14 ps=1.28 w=1 l=0.6
X108 a_4347_7368# DM_H[0] VCC_IO VCC_IO sky130_fd_pr__pfet_g5v0d10v5 ad=0.14 pd=1.28 as=0.265 ps=2.53 w=1 l=0.6
X109 a_4520_6066# DM_H_N[0] a_4520_5728# VGND sky130_fd_pr__nfet_g5v0d10v5 ad=0.1855 pd=1.93 as=0.098 ps=0.98 w=0.7 l=0.6
X110 VCC_IO DM_H[0] a_5052_5702# VCC_IO sky130_fd_pr__pfet_g5v0d10v5 ad=0.265 pd=2.53 as=0.14 ps=1.28 w=1 l=0.6
X111 a_5513_4576# a_3871_7368# VCC_IO VCC_IO sky130_fd_pr__pfet_g5v0d10v5 ad=0.265 pd=2.53 as=0.265 ps=2.53 w=1 l=0.6
X112 VGND a_4347_7368# a_5651_5728# VGND sky130_fd_pr__nfet_g5v0d10v5 ad=0.098 pd=0.98 as=0.1855 ps=1.93 w=0.7 l=0.6
X113 a_n8931_2384# a_n9051_2020# a_n9107_2384# w_n9346_2317# sky130_fd_pr__pfet_g5v0d10v5 ad=0.14 pd=1.28 as=0.14 ps=1.28 w=1 l=0.6
X114 VCC_IO a_4458_3414# a_5488_3924# VCC_IO sky130_fd_pr__pfet_g5v0d10v5 ad=0.14 pd=1.28 as=0.14 ps=1.28 w=1 l=0.6
X115 a_4044_7368# a_3924_6676# a_3871_7368# VGND sky130_fd_pr__nfet_g5v0d10v5 ad=0.098 pd=0.98 as=0.1855 ps=1.93 w=0.7 l=0.6
X116 a_4872_7368# DM_H_N[2] VGND VGND sky130_fd_pr__nfet_g5v0d10v5 ad=0.098 pd=0.98 as=0.098 ps=0.98 w=0.7 l=0.6
X117 a_5693_4550# a_5513_4576# VGND VGND sky130_fd_pr__nfet_g5v0d10v5 ad=0.1855 pd=1.93 as=0.098 ps=0.98 w=0.7 l=0.6
X118 a_4458_3414# DM_H[0] a_4282_3414# VGND sky130_fd_pr__nfet_g5v0d10v5 ad=0.098 pd=0.98 as=0.098 ps=0.98 w=0.7 l=0.6
X119 VCC_IO DM_H[0] a_4634_3816# VCC_IO sky130_fd_pr__pfet_g5v0d10v5 ad=0.14 pd=1.28 as=0.14 ps=1.28 w=1 l=0.6
X120 VCC_IO DM_H[1] a_4347_7368# VCC_IO sky130_fd_pr__pfet_g5v0d10v5 ad=0.14 pd=1.28 as=0.14 ps=1.28 w=1 l=0.6
X121 a_4520_6066# a_3871_6066# VCC_IO VCC_IO sky130_fd_pr__pfet_g5v0d10v5 ad=0.14 pd=1.28 as=0.265 ps=2.53 w=1 l=0.6
X122 a_3871_6066# DM_H_N[1] VGND VGND sky130_fd_pr__nfet_g5v0d10v5 ad=0.098 pd=0.98 as=0.196 ps=1.96 w=0.7 l=0.6
X123 VCC_IO DM_H_N[1] a_4872_6702# VCC_IO sky130_fd_pr__pfet_g5v0d10v5 ad=0.265 pd=2.53 as=0.14 ps=1.28 w=1 l=0.6
X124 VCC_IO a_5175_7368# a_5651_6702# VCC_IO sky130_fd_pr__pfet_g5v0d10v5 ad=0.14 pd=1.28 as=0.265 ps=2.53 w=1 l=0.6
X125 VCC_IO DM_H_N[2] a_4044_6066# VCC_IO sky130_fd_pr__pfet_g5v0d10v5 ad=0.265 pd=2.53 as=0.14 ps=1.28 w=1 l=0.6
X126 VCC_IO PUEN_2OR1_H a_3871_7368# VCC_IO sky130_fd_pr__pfet_g5v0d10v5 ad=0.265 pd=2.53 as=0.14 ps=1.28 w=1 l=0.6
X127 a_5720_3560# a_5315_3924# VCC_IO VCC_IO sky130_fd_pr__pfet_g5v0d10v5 ad=0.265 pd=2.53 as=0.14 ps=1.28 w=1 l=0.6
X128 VCC_IO a_5693_4550# a_5813_4576# VCC_IO sky130_fd_pr__pfet_g5v0d10v5 ad=0.14 pd=1.28 as=0.14 ps=1.28 w=1 l=0.6
X129 a_5052_5702# a_4491_4619# VCC_IO VCC_IO sky130_fd_pr__pfet_g5v0d10v5 ad=0.14 pd=1.28 as=0.14 ps=1.28 w=1 l=0.6
X130 a_5840_3586# a_5720_3560# VCC_IO VCC_IO sky130_fd_pr__pfet_g5v0d10v5 ad=0.14 pd=1.28 as=0.14 ps=1.28 w=1 l=0.6
X131 a_5175_7368# a_4872_6702# VCC_IO VCC_IO sky130_fd_pr__pfet_g5v0d10v5 ad=0.14 pd=1.28 as=0.265 ps=2.53 w=1 l=0.6
X132 VCC_IO a_5651_5728# PDEN_H_N[0] VCC_IO sky130_fd_pr__pfet_g5v0d10v5 ad=0.265 pd=2.53 as=0.14 ps=1.28 w=1 l=0.6
X133 a_4458_3414# a_4338_3622# a_4282_3816# VCC_IO sky130_fd_pr__pfet_g5v0d10v5 ad=0.14 pd=1.28 as=0.14 ps=1.28 w=1 l=0.6
X134 VCC_IO a_5651_6702# PDEN_H_N[1] VCC_IO sky130_fd_pr__pfet_g5v0d10v5 ad=0.265 pd=2.53 as=0.14 ps=1.28 w=1 l=0.6
X135 a_4315_4619# DM_H[2] VCC_IO VCC_IO sky130_fd_pr__pfet_g5v0d10v5 ad=0.14 pd=1.28 as=0.14 ps=1.28 w=1 l=0.6
X136 VGND DM_H[2] a_3966_4619# VGND sky130_fd_pr__nfet_g5v0d10v5 ad=0.098 pd=0.98 as=0.1855 ps=1.93 w=0.7 l=0.6
X137 a_4667_4619# a_3966_4619# a_4491_4619# VCC_IO sky130_fd_pr__pfet_g5v0d10v5 ad=0.14 pd=1.28 as=0.14 ps=1.28 w=1 l=0.6
X138 a_5720_3560# a_5315_3924# VGND VGND sky130_fd_pr__nfet_g5v0d10v5 ad=0.1855 pd=1.93 as=0.098 ps=0.98 w=0.7 l=0.6
X139 a_4282_3414# DM_H[2] VGND VGND sky130_fd_pr__nfet_g5v0d10v5 ad=0.098 pd=0.98 as=0.098 ps=0.98 w=0.7 l=0.6
X140 VCC_IO DM_H[2] a_3933_3414# VCC_IO sky130_fd_pr__pfet_g5v0d10v5 ad=0.14 pd=1.28 as=0.265 ps=2.53 w=1 l=0.6
.ends

.subckt sky130_fd_io__gpio_dat_ls_1v2 OUT_H_N RST_H SET_H HLD_H_N VCC_IO VGND OUT_H
+ VPWR_KA IN
X0 a_2251_36# a_2251_2228# VGND VGND sky130_fd_pr__nfet_01v8 ad=0.14 pd=1.28 as=0.265 ps=2.53 w=1 l=0.25
X1 a_28_633# SET_H VGND VGND sky130_fd_pr__nfet_g5v0d10v5 ad=0.795 pd=6.53 as=0.42 ps=3.28 w=3 l=0.6
X2 a_1720_1202# HLD_H_N a_28_14# VGND sky130_fd_pr__nfet_g5v0d10v5 ad=1.325 pd=10.53 as=1.325 ps=10.53 w=5 l=0.5
X3 a_1251_128# VPWR_KA a_1484_128# VGND sky130_fd_pr__nfet_05v0_nvt ad=0.265 pd=2.53 as=0.14 ps=1.28 w=1 l=0.9
X4 a_2080_128# VPWR_KA a_1720_1202# VGND sky130_fd_pr__nfet_05v0_nvt ad=0.265 pd=2.53 as=0.265 ps=2.53 w=1 l=0.9
X5 a_1484_128# VPWR_KA a_1251_128# VGND sky130_fd_pr__nfet_05v0_nvt ad=0.14 pd=1.28 as=0.265 ps=2.53 w=1 l=0.9
X6 a_2080_128# a_2251_2228# VGND VGND sky130_fd_pr__nfet_01v8_lvt ad=0.14 pd=1.28 as=0.265 ps=2.53 w=1 l=0.15
X7 VGND a_2251_2228# a_2080_128# VGND sky130_fd_pr__nfet_01v8_lvt ad=0.265 pd=2.53 as=0.14 ps=1.28 w=1 l=0.15
X8 a_1484_128# a_2251_36# VGND VGND sky130_fd_pr__nfet_01v8_lvt ad=0.14 pd=1.28 as=0.265 ps=2.53 w=1 l=0.15
X9 VGND a_2251_36# a_1484_128# VGND sky130_fd_pr__nfet_01v8_lvt ad=0.265 pd=2.53 as=0.14 ps=1.28 w=1 l=0.15
X10 VPWR_KA a_2251_2228# a_2251_36# VPWR_KA sky130_fd_pr__pfet_01v8_hvt ad=0.42 pd=3.28 as=0.795 ps=6.53 w=3 l=0.25
X11 a_2080_128# VPWR_KA a_1720_1202# VGND sky130_fd_pr__nfet_05v0_nvt ad=0.265 pd=2.53 as=0.265 ps=2.53 w=1 l=0.9
X12 a_2080_128# VPWR_KA a_1720_1202# VGND sky130_fd_pr__nfet_05v0_nvt ad=0.265 pd=2.53 as=0.265 ps=2.53 w=1 l=0.9
X13 a_1251_128# VPWR_KA a_1484_128# VGND sky130_fd_pr__nfet_05v0_nvt ad=0.265 pd=2.53 as=0.14 ps=1.28 w=1 l=0.9
X14 a_28_633# a_28_14# VCC_IO VCC_IO sky130_fd_pr__pfet_g5v0d10v5 ad=0.265 pd=2.53 as=0.265 ps=2.53 w=1 l=0.5
X15 VGND IN a_2251_2228# VGND sky130_fd_pr__nfet_01v8 ad=0.265 pd=2.53 as=0.14 ps=1.28 w=1 l=0.25
X16 OUT_H a_28_633# VCC_IO VCC_IO sky130_fd_pr__pfet_g5v0d10v5 ad=0.795 pd=6.53 as=0.42 ps=3.28 w=3 l=0.5
X17 a_1484_128# a_2251_36# VGND VGND sky130_fd_pr__nfet_01v8_lvt ad=0.14 pd=1.28 as=0.265 ps=2.53 w=1 l=0.15
X18 a_2080_128# a_2251_2228# VGND VGND sky130_fd_pr__nfet_01v8_lvt ad=0.14 pd=1.28 as=0.265 ps=2.53 w=1 l=0.15
X19 a_2080_128# VPWR_KA a_1720_1202# VGND sky130_fd_pr__nfet_05v0_nvt ad=0.265 pd=2.53 as=0.265 ps=2.53 w=1 l=0.9
X20 a_1251_128# VPWR_KA a_1484_128# VGND sky130_fd_pr__nfet_05v0_nvt ad=0.265 pd=2.53 as=0.14 ps=1.28 w=1 l=0.9
X21 a_1484_128# VPWR_KA a_1251_128# VGND sky130_fd_pr__nfet_05v0_nvt ad=0.14 pd=1.28 as=0.265 ps=2.53 w=1 l=0.9
X22 VGND a_2251_36# a_1484_128# VGND sky130_fd_pr__nfet_01v8_lvt ad=0.265 pd=2.53 as=0.14 ps=1.28 w=1 l=0.15
X23 VGND a_28_633# OUT_H VGND sky130_fd_pr__nfet_g5v0d10v5 ad=0.14 pd=1.28 as=0.28 ps=2.56 w=1 l=0.6
X24 a_1484_128# a_2251_36# VGND VGND sky130_fd_pr__nfet_01v8_lvt ad=0.14 pd=1.28 as=0.265 ps=2.53 w=1 l=0.15
X25 VGND a_2251_2228# a_2080_128# VGND sky130_fd_pr__nfet_01v8_lvt ad=0.265 pd=2.53 as=0.14 ps=1.28 w=1 l=0.15
X26 a_2251_2228# IN VGND VGND sky130_fd_pr__nfet_01v8 ad=0.14 pd=1.28 as=0.14 ps=1.28 w=1 l=0.25
X27 a_2080_128# VPWR_KA a_1720_1202# VGND sky130_fd_pr__nfet_05v0_nvt ad=0.265 pd=2.53 as=0.265 ps=2.53 w=1 l=0.9
X28 a_1484_128# VPWR_KA a_1251_128# VGND sky130_fd_pr__nfet_05v0_nvt ad=0.14 pd=1.28 as=0.265 ps=2.53 w=1 l=0.9
X29 a_2080_128# VPWR_KA a_1720_1202# VGND sky130_fd_pr__nfet_05v0_nvt ad=0.265 pd=2.53 as=0.265 ps=2.53 w=1 l=0.9
X30 VGND a_2251_36# a_1484_128# VGND sky130_fd_pr__nfet_01v8_lvt ad=0.265 pd=2.53 as=0.14 ps=1.28 w=1 l=0.15
X31 VGND a_28_633# a_28_14# VGND sky130_fd_pr__nfet_g5v0d10v5 ad=0.098 pd=0.98 as=0.1855 ps=1.93 w=0.7 l=0.6
X32 a_2251_2228# IN VPWR_KA VPWR_KA sky130_fd_pr__pfet_01v8_hvt ad=0.795 pd=6.53 as=0.42 ps=3.28 w=3 l=0.25
X33 a_2080_128# a_2251_2228# VGND VGND sky130_fd_pr__nfet_01v8_lvt ad=0.14 pd=1.28 as=0.265 ps=2.53 w=1 l=0.15
X34 a_1484_128# VPWR_KA a_1251_128# VGND sky130_fd_pr__nfet_05v0_nvt ad=0.14 pd=1.28 as=0.265 ps=2.53 w=1 l=0.9
X35 VGND a_2251_36# a_1484_128# VGND sky130_fd_pr__nfet_01v8_lvt ad=0.265 pd=2.53 as=0.14 ps=1.28 w=1 l=0.15
X36 a_28_633# a_28_14# VGND VGND sky130_fd_pr__nfet_g5v0d10v5 ad=0.1855 pd=1.93 as=0.098 ps=0.98 w=0.7 l=0.6
X37 a_28_14# a_28_633# VCC_IO VCC_IO sky130_fd_pr__pfet_g5v0d10v5 ad=0.265 pd=2.53 as=0.265 ps=2.53 w=1 l=0.5
X38 VGND a_2251_2228# a_2251_36# VGND sky130_fd_pr__nfet_01v8 ad=0.14 pd=1.28 as=0.14 ps=1.28 w=1 l=0.25
X39 a_1251_128# VPWR_KA a_1484_128# VGND sky130_fd_pr__nfet_05v0_nvt ad=0.265 pd=2.53 as=0.14 ps=1.28 w=1 l=0.9
X40 VGND a_2251_2228# a_2080_128# VGND sky130_fd_pr__nfet_01v8_lvt ad=0.265 pd=2.53 as=0.14 ps=1.28 w=1 l=0.15
X41 a_1251_128# HLD_H_N a_28_633# VGND sky130_fd_pr__nfet_g5v0d10v5 ad=1.4 pd=10.56 as=1.325 ps=10.53 w=5 l=0.5
X42 VCC_IO a_28_14# OUT_H_N VCC_IO sky130_fd_pr__pfet_g5v0d10v5 ad=0.42 pd=3.28 as=0.795 ps=6.53 w=3 l=0.5
X43 a_1484_128# a_2251_36# VGND VGND sky130_fd_pr__nfet_01v8_lvt ad=0.14 pd=1.28 as=0.265 ps=2.53 w=1 l=0.15
X44 a_2080_128# VPWR_KA a_1720_1202# VGND sky130_fd_pr__nfet_05v0_nvt ad=0.265 pd=2.53 as=0.265 ps=2.53 w=1 l=0.9
X45 a_2080_128# VPWR_KA a_1720_1202# VGND sky130_fd_pr__nfet_05v0_nvt ad=0.265 pd=2.53 as=0.265 ps=2.53 w=1 l=0.9
X46 VGND RST_H a_28_14# VGND sky130_fd_pr__nfet_g5v0d10v5 ad=0.42 pd=3.28 as=0.795 ps=6.53 w=3 l=0.6
X47 OUT_H_N a_28_14# VGND VGND sky130_fd_pr__nfet_g5v0d10v5 ad=0.28 pd=2.56 as=0.14 ps=1.28 w=1 l=0.6
X48 a_2080_128# a_2251_2228# VGND VGND sky130_fd_pr__nfet_01v8_lvt ad=0.14 pd=1.28 as=0.265 ps=2.53 w=1 l=0.15
X49 VGND a_2251_2228# a_2080_128# VGND sky130_fd_pr__nfet_01v8_lvt ad=0.265 pd=2.53 as=0.14 ps=1.28 w=1 l=0.15
.ends

.subckt sky130_fd_io__gpio_dat_lsv2 OUT_H_N RST_H SET_H HLD_H_N VCC_IO VGND OUT_H
+ VPWR_KA IN a_28_14#
X0 a_2251_36# a_2251_2228# VGND VGND sky130_fd_pr__nfet_01v8 ad=0.14 pd=1.28 as=0.265 ps=2.53 w=1 l=0.25
X1 a_28_633# SET_H VGND VGND sky130_fd_pr__nfet_g5v0d10v5 ad=0.795 pd=6.53 as=0.42 ps=3.28 w=3 l=0.6
X2 a_1720_1202# HLD_H_N a_28_14# VGND sky130_fd_pr__nfet_g5v0d10v5 ad=1.325 pd=10.53 as=1.325 ps=10.53 w=5 l=0.5
X3 a_1251_128# VPWR_KA a_1484_128# VGND sky130_fd_pr__nfet_05v0_nvt ad=0.265 pd=2.53 as=0.14 ps=1.28 w=1 l=0.9
X4 a_2080_128# VPWR_KA a_1720_1202# VGND sky130_fd_pr__nfet_05v0_nvt ad=0.265 pd=2.53 as=0.265 ps=2.53 w=1 l=0.9
X5 a_1484_128# VPWR_KA a_1251_128# VGND sky130_fd_pr__nfet_05v0_nvt ad=0.14 pd=1.28 as=0.265 ps=2.53 w=1 l=0.9
X6 a_2080_128# a_2251_2228# VGND VGND sky130_fd_pr__nfet_01v8_lvt ad=0.14 pd=1.28 as=0.265 ps=2.53 w=1 l=0.15
X7 VGND a_2251_2228# a_2080_128# VGND sky130_fd_pr__nfet_01v8_lvt ad=0.265 pd=2.53 as=0.14 ps=1.28 w=1 l=0.15
X8 a_1484_128# a_2251_36# VGND VGND sky130_fd_pr__nfet_01v8_lvt ad=0.14 pd=1.28 as=0.265 ps=2.53 w=1 l=0.15
X9 VGND a_2251_36# a_1484_128# VGND sky130_fd_pr__nfet_01v8_lvt ad=0.265 pd=2.53 as=0.14 ps=1.28 w=1 l=0.15
X10 VPWR_KA a_2251_2228# a_2251_36# VPWR_KA sky130_fd_pr__pfet_01v8_hvt ad=0.42 pd=3.28 as=0.795 ps=6.53 w=3 l=0.25
X11 a_2080_128# VPWR_KA a_1720_1202# VGND sky130_fd_pr__nfet_05v0_nvt ad=0.265 pd=2.53 as=0.265 ps=2.53 w=1 l=0.9
X12 a_2080_128# VPWR_KA a_1720_1202# VGND sky130_fd_pr__nfet_05v0_nvt ad=0.265 pd=2.53 as=0.265 ps=2.53 w=1 l=0.9
X13 a_1251_128# VPWR_KA a_1484_128# VGND sky130_fd_pr__nfet_05v0_nvt ad=0.265 pd=2.53 as=0.14 ps=1.28 w=1 l=0.9
X14 a_28_633# a_28_14# VCC_IO VCC_IO sky130_fd_pr__pfet_g5v0d10v5 ad=0.265 pd=2.53 as=0.265 ps=2.53 w=1 l=0.5
X15 VGND IN a_2251_2228# VGND sky130_fd_pr__nfet_01v8 ad=0.265 pd=2.53 as=0.14 ps=1.28 w=1 l=0.25
X16 OUT_H a_28_633# VCC_IO VCC_IO sky130_fd_pr__pfet_g5v0d10v5 ad=0.795 pd=6.53 as=0.42 ps=3.28 w=3 l=0.5
X17 a_1484_128# a_2251_36# VGND VGND sky130_fd_pr__nfet_01v8_lvt ad=0.14 pd=1.28 as=0.265 ps=2.53 w=1 l=0.15
X18 a_2080_128# a_2251_2228# VGND VGND sky130_fd_pr__nfet_01v8_lvt ad=0.14 pd=1.28 as=0.265 ps=2.53 w=1 l=0.15
X19 a_2080_128# VPWR_KA a_1720_1202# VGND sky130_fd_pr__nfet_05v0_nvt ad=0.265 pd=2.53 as=0.265 ps=2.53 w=1 l=0.9
X20 a_1251_128# VPWR_KA a_1484_128# VGND sky130_fd_pr__nfet_05v0_nvt ad=0.265 pd=2.53 as=0.14 ps=1.28 w=1 l=0.9
X21 a_1484_128# VPWR_KA a_1251_128# VGND sky130_fd_pr__nfet_05v0_nvt ad=0.14 pd=1.28 as=0.265 ps=2.53 w=1 l=0.9
X22 VGND a_2251_36# a_1484_128# VGND sky130_fd_pr__nfet_01v8_lvt ad=0.265 pd=2.53 as=0.14 ps=1.28 w=1 l=0.15
X23 VGND a_28_633# OUT_H VGND sky130_fd_pr__nfet_g5v0d10v5 ad=0.14 pd=1.28 as=0.28 ps=2.56 w=1 l=0.6
X24 a_1484_128# a_2251_36# VGND VGND sky130_fd_pr__nfet_01v8_lvt ad=0.14 pd=1.28 as=0.265 ps=2.53 w=1 l=0.15
X25 VGND a_2251_2228# a_2080_128# VGND sky130_fd_pr__nfet_01v8_lvt ad=0.265 pd=2.53 as=0.14 ps=1.28 w=1 l=0.15
X26 a_2251_2228# IN VGND VGND sky130_fd_pr__nfet_01v8 ad=0.14 pd=1.28 as=0.14 ps=1.28 w=1 l=0.25
X27 a_2080_128# VPWR_KA a_1720_1202# VGND sky130_fd_pr__nfet_05v0_nvt ad=0.265 pd=2.53 as=0.265 ps=2.53 w=1 l=0.9
X28 a_1484_128# VPWR_KA a_1251_128# VGND sky130_fd_pr__nfet_05v0_nvt ad=0.14 pd=1.28 as=0.265 ps=2.53 w=1 l=0.9
X29 a_2080_128# VPWR_KA a_1720_1202# VGND sky130_fd_pr__nfet_05v0_nvt ad=0.265 pd=2.53 as=0.265 ps=2.53 w=1 l=0.9
X30 VGND a_2251_36# a_1484_128# VGND sky130_fd_pr__nfet_01v8_lvt ad=0.265 pd=2.53 as=0.14 ps=1.28 w=1 l=0.15
X31 VGND a_28_633# a_28_14# VGND sky130_fd_pr__nfet_g5v0d10v5 ad=0.098 pd=0.98 as=0.1855 ps=1.93 w=0.7 l=0.6
X32 a_2251_2228# IN VPWR_KA VPWR_KA sky130_fd_pr__pfet_01v8_hvt ad=0.795 pd=6.53 as=0.42 ps=3.28 w=3 l=0.25
X33 a_2080_128# a_2251_2228# VGND VGND sky130_fd_pr__nfet_01v8_lvt ad=0.14 pd=1.28 as=0.265 ps=2.53 w=1 l=0.15
X34 a_1484_128# VPWR_KA a_1251_128# VGND sky130_fd_pr__nfet_05v0_nvt ad=0.14 pd=1.28 as=0.265 ps=2.53 w=1 l=0.9
X35 VGND a_2251_36# a_1484_128# VGND sky130_fd_pr__nfet_01v8_lvt ad=0.265 pd=2.53 as=0.14 ps=1.28 w=1 l=0.15
X36 a_28_633# a_28_14# VGND VGND sky130_fd_pr__nfet_g5v0d10v5 ad=0.1855 pd=1.93 as=0.098 ps=0.98 w=0.7 l=0.6
X37 a_28_14# a_28_633# VCC_IO VCC_IO sky130_fd_pr__pfet_g5v0d10v5 ad=0.265 pd=2.53 as=0.265 ps=2.53 w=1 l=0.5
X38 VGND a_2251_2228# a_2251_36# VGND sky130_fd_pr__nfet_01v8 ad=0.14 pd=1.28 as=0.14 ps=1.28 w=1 l=0.25
X39 a_1251_128# VPWR_KA a_1484_128# VGND sky130_fd_pr__nfet_05v0_nvt ad=0.265 pd=2.53 as=0.14 ps=1.28 w=1 l=0.9
X40 VGND a_2251_2228# a_2080_128# VGND sky130_fd_pr__nfet_01v8_lvt ad=0.265 pd=2.53 as=0.14 ps=1.28 w=1 l=0.15
X41 a_1251_128# HLD_H_N a_28_633# VGND sky130_fd_pr__nfet_g5v0d10v5 ad=1.4 pd=10.56 as=1.325 ps=10.53 w=5 l=0.5
X42 VCC_IO a_28_14# OUT_H_N VCC_IO sky130_fd_pr__pfet_g5v0d10v5 ad=0.42 pd=3.28 as=0.795 ps=6.53 w=3 l=0.5
X43 a_1484_128# a_2251_36# VGND VGND sky130_fd_pr__nfet_01v8_lvt ad=0.14 pd=1.28 as=0.265 ps=2.53 w=1 l=0.15
X44 a_2080_128# VPWR_KA a_1720_1202# VGND sky130_fd_pr__nfet_05v0_nvt ad=0.265 pd=2.53 as=0.265 ps=2.53 w=1 l=0.9
X45 a_2080_128# VPWR_KA a_1720_1202# VGND sky130_fd_pr__nfet_05v0_nvt ad=0.265 pd=2.53 as=0.265 ps=2.53 w=1 l=0.9
X46 VGND RST_H a_28_14# VGND sky130_fd_pr__nfet_g5v0d10v5 ad=0.42 pd=3.28 as=0.795 ps=6.53 w=3 l=0.6
X47 OUT_H_N a_28_14# VGND VGND sky130_fd_pr__nfet_g5v0d10v5 ad=0.28 pd=2.56 as=0.14 ps=1.28 w=1 l=0.6
X48 a_2080_128# a_2251_2228# VGND VGND sky130_fd_pr__nfet_01v8_lvt ad=0.14 pd=1.28 as=0.265 ps=2.53 w=1 l=0.15
X49 VGND a_2251_2228# a_2080_128# VGND sky130_fd_pr__nfet_01v8_lvt ad=0.265 pd=2.53 as=0.14 ps=1.28 w=1 l=0.15
.ends

.subckt sky130_fd_io__com_cclat PU_DIS_H PD_DIS_H VGND OE_H_N DRVLO_H_N DRVHI_H VCC_IO
X0 a_947_1193# DRVLO_H_N VCC_IO VCC_IO sky130_fd_pr__pfet_g5v0d10v5 ad=1.325 pd=10.53 as=0.7 ps=5.28 w=5 l=0.5
X1 VCC_IO a_505_1193# a_3417_1193# VCC_IO sky130_fd_pr__pfet_g5v0d10v5 ad=0.7 pd=5.28 as=0.7 ps=5.28 w=5 l=0.6
X2 VCC_IO a_505_1193# a_3417_1193# VCC_IO sky130_fd_pr__pfet_g5v0d10v5 ad=0.7 pd=5.28 as=0.7 ps=5.28 w=5 l=0.6
X3 a_3417_1193# DRVHI_H a_4762_1193# VCC_IO sky130_fd_pr__pfet_g5v0d10v5 ad=0.7 pd=5.28 as=0.7 ps=5.28 w=5 l=0.5
X4 a_4762_1193# DRVHI_H a_3417_1193# VCC_IO sky130_fd_pr__pfet_g5v0d10v5 ad=0.7 pd=5.28 as=0.7 ps=5.28 w=5 l=0.5
X5 VGND DRVHI_H a_2361_1095# VGND sky130_fd_pr__nfet_g5v0d10v5 ad=0.42 pd=3.28 as=0.42 ps=3.28 w=3 l=0.6
X6 VCC_IO PU_DIS_H a_638_279# VCC_IO sky130_fd_pr__pfet_g5v0d10v5 ad=0.7 pd=5.28 as=1.325 ps=10.53 w=5 l=0.5
X7 VCC_IO a_2361_1095# DRVLO_H_N VCC_IO sky130_fd_pr__pfet_g5v0d10v5 ad=0.7 pd=5.28 as=0.7 ps=5.28 w=5 l=0.5
X8 DRVLO_H_N a_2361_1095# VCC_IO VCC_IO sky130_fd_pr__pfet_g5v0d10v5 ad=0.7 pd=5.28 as=0.7 ps=5.28 w=5 l=0.5
X9 DRVHI_H a_947_1193# VGND VGND sky130_fd_pr__nfet_g5v0d10v5 ad=0.42 pd=3.28 as=0.42 ps=3.28 w=3 l=0.6
X10 a_2361_1095# DRVHI_H VGND VGND sky130_fd_pr__nfet_g5v0d10v5 ad=0.42 pd=3.28 as=0.42 ps=3.28 w=3 l=0.6
X11 VCC_IO a_947_1193# DRVHI_H VCC_IO sky130_fd_pr__pfet_g5v0d10v5 ad=0.7 pd=5.28 as=0.7 ps=5.28 w=5 l=0.5
X12 DRVLO_H_N a_2361_1095# VCC_IO VCC_IO sky130_fd_pr__pfet_g5v0d10v5 ad=0.7 pd=5.28 as=0.7 ps=5.28 w=5 l=0.5
X13 VCC_IO a_2361_1095# DRVLO_H_N VCC_IO sky130_fd_pr__pfet_g5v0d10v5 ad=0.7 pd=5.28 as=0.7 ps=5.28 w=5 l=0.5
X14 DRVHI_H a_947_1193# VCC_IO VCC_IO sky130_fd_pr__pfet_g5v0d10v5 ad=0.7 pd=5.28 as=1.325 ps=10.53 w=5 l=0.5
X15 VCC_IO a_947_1193# DRVHI_H VCC_IO sky130_fd_pr__pfet_g5v0d10v5 ad=0.7 pd=5.28 as=0.7 ps=5.28 w=5 l=0.5
X16 VGND PU_DIS_H a_638_279# VGND sky130_fd_pr__nfet_g5v0d10v5 ad=0.42 pd=3.28 as=0.795 ps=6.53 w=3 l=0.6
X17 a_4762_1193# DRVHI_H a_3417_1193# VCC_IO sky130_fd_pr__pfet_g5v0d10v5 ad=0.7 pd=5.28 as=0.7 ps=5.28 w=5 l=0.5
X18 a_2361_1095# PD_DIS_H a_4762_1193# VCC_IO sky130_fd_pr__pfet_g5v0d10v5 ad=0.7 pd=5.28 as=0.7 ps=5.28 w=5 l=0.5
X19 VGND PD_DIS_H a_2361_1095# VGND sky130_fd_pr__nfet_g5v0d10v5 ad=0.795 pd=6.53 as=0.42 ps=3.28 w=3 l=0.6
X20 a_505_1193# a_176_279# VCC_IO VCC_IO sky130_fd_pr__pfet_g5v0d10v5 ad=1.325 pd=10.53 as=0.7 ps=5.28 w=5 l=0.5
X21 a_3417_1193# DRVHI_H a_4762_1193# VCC_IO sky130_fd_pr__pfet_g5v0d10v5 ad=0.7 pd=5.28 as=1.325 ps=10.53 w=5 l=0.5
X22 a_2361_1095# PD_DIS_H VGND VGND sky130_fd_pr__nfet_g5v0d10v5 ad=0.42 pd=3.28 as=0.42 ps=3.28 w=3 l=0.6
X23 VCC_IO a_638_279# a_947_1193# VCC_IO sky130_fd_pr__pfet_g5v0d10v5 ad=0.7 pd=5.28 as=0.7 ps=5.28 w=5 l=0.5
X24 VGND a_947_1193# DRVHI_H VGND sky130_fd_pr__nfet_g5v0d10v5 ad=0.42 pd=3.28 as=0.42 ps=3.28 w=3 l=0.6
X25 DRVLO_H_N a_2361_1095# VGND VGND sky130_fd_pr__nfet_g5v0d10v5 ad=0.42 pd=3.28 as=0.795 ps=6.53 w=3 l=0.6
X26 VGND a_947_1193# DRVHI_H VGND sky130_fd_pr__nfet_g5v0d10v5 ad=0.42 pd=3.28 as=0.42 ps=3.28 w=3 l=0.6
X27 a_987_279# a_176_279# VGND VGND sky130_fd_pr__nfet_g5v0d10v5 ad=0.42 pd=3.28 as=0.42 ps=3.28 w=3 l=0.6
X28 DRVHI_H a_947_1193# VCC_IO VCC_IO sky130_fd_pr__pfet_g5v0d10v5 ad=0.7 pd=5.28 as=0.7 ps=5.28 w=5 l=0.5
X29 a_4762_1193# PD_DIS_H a_2361_1095# VCC_IO sky130_fd_pr__pfet_g5v0d10v5 ad=0.7 pd=5.28 as=0.7 ps=5.28 w=5 l=0.5
X30 DRVHI_H a_947_1193# VGND VGND sky130_fd_pr__nfet_g5v0d10v5 ad=0.42 pd=3.28 as=0.42 ps=3.28 w=3 l=0.6
X31 VCC_IO OE_H_N a_176_279# VCC_IO sky130_fd_pr__pfet_g5v0d10v5 ad=0.7 pd=5.28 as=1.325 ps=10.53 w=5 l=0.5
X32 a_3417_1193# a_505_1193# VCC_IO VCC_IO sky130_fd_pr__pfet_g5v0d10v5 ad=0.7 pd=5.28 as=0.7 ps=5.28 w=5 l=0.6
X33 a_2361_1095# PD_DIS_H a_4762_1193# VCC_IO sky130_fd_pr__pfet_g5v0d10v5 ad=0.7 pd=5.28 as=0.7 ps=5.28 w=5 l=0.5
X34 a_987_279# DRVLO_H_N a_1628_279# VGND sky130_fd_pr__nfet_g5v0d10v5 ad=0.42 pd=3.28 as=0.795 ps=6.53 w=3 l=0.6
X35 VGND a_2361_1095# DRVLO_H_N VGND sky130_fd_pr__nfet_g5v0d10v5 ad=0.42 pd=3.28 as=0.42 ps=3.28 w=3 l=0.6
X36 a_947_1193# a_176_279# VCC_IO VCC_IO sky130_fd_pr__pfet_g5v0d10v5 ad=0.7 pd=5.28 as=0.7 ps=5.28 w=5 l=0.5
X37 DRVHI_H a_947_1193# VGND VGND sky130_fd_pr__nfet_g5v0d10v5 ad=0.42 pd=3.28 as=0.42 ps=3.28 w=3 l=0.6
X38 VGND OE_H_N a_176_279# VGND sky130_fd_pr__nfet_g5v0d10v5 ad=0.42 pd=3.28 as=0.795 ps=6.53 w=3 l=0.6
X39 VCC_IO a_947_1193# DRVHI_H VCC_IO sky130_fd_pr__pfet_g5v0d10v5 ad=0.7 pd=5.28 as=0.7 ps=5.28 w=5 l=0.5
X40 VCC_IO a_2361_1095# DRVLO_H_N VCC_IO sky130_fd_pr__pfet_g5v0d10v5 ad=0.7 pd=5.28 as=0.7 ps=5.28 w=5 l=0.5
X41 DRVLO_H_N a_2361_1095# VCC_IO VCC_IO sky130_fd_pr__pfet_g5v0d10v5 ad=0.7 pd=5.28 as=0.7 ps=5.28 w=5 l=0.5
X42 VCC_IO a_505_1193# a_3417_1193# VCC_IO sky130_fd_pr__pfet_g5v0d10v5 ad=0.7 pd=5.28 as=0.7 ps=5.28 w=5 l=0.6
X43 DRVHI_H a_947_1193# VCC_IO VCC_IO sky130_fd_pr__pfet_g5v0d10v5 ad=0.7 pd=5.28 as=0.7 ps=5.28 w=5 l=0.5
X44 VCC_IO a_505_1193# a_3417_1193# VCC_IO sky130_fd_pr__pfet_g5v0d10v5 ad=1.325 pd=10.53 as=0.7 ps=5.28 w=5 l=0.6
X45 a_4762_1193# PD_DIS_H a_2361_1095# VCC_IO sky130_fd_pr__pfet_g5v0d10v5 ad=1.325 pd=10.53 as=0.7 ps=5.28 w=5 l=0.5
X46 VGND a_947_1193# DRVHI_H VGND sky130_fd_pr__nfet_g5v0d10v5 ad=0.42 pd=3.28 as=0.42 ps=3.28 w=3 l=0.6
X47 VGND a_176_279# a_987_279# VGND sky130_fd_pr__nfet_g5v0d10v5 ad=0.42 pd=3.28 as=0.42 ps=3.28 w=3 l=0.6
X48 a_947_1193# a_638_279# a_1628_279# VGND sky130_fd_pr__nfet_g5v0d10v5 ad=0.42 pd=3.28 as=0.42 ps=3.28 w=3 l=0.6
X49 VGND a_2361_1095# DRVLO_H_N VGND sky130_fd_pr__nfet_g5v0d10v5 ad=0.42 pd=3.28 as=0.42 ps=3.28 w=3 l=0.6
X50 DRVLO_H_N a_2361_1095# VGND VGND sky130_fd_pr__nfet_g5v0d10v5 ad=0.42 pd=3.28 as=0.42 ps=3.28 w=3 l=0.6
X51 a_3417_1193# a_505_1193# VCC_IO VCC_IO sky130_fd_pr__pfet_g5v0d10v5 ad=0.7 pd=5.28 as=0.7 ps=5.28 w=5 l=0.6
X52 a_505_1193# a_176_279# VGND VGND sky130_fd_pr__nfet_g5v0d10v5 ad=0.795 pd=6.53 as=0.42 ps=3.28 w=3 l=0.6
X53 a_1628_279# DRVLO_H_N a_987_279# VGND sky130_fd_pr__nfet_g5v0d10v5 ad=0.42 pd=3.28 as=0.42 ps=3.28 w=3 l=0.6
X54 DRVLO_H_N a_2361_1095# VGND VGND sky130_fd_pr__nfet_g5v0d10v5 ad=0.42 pd=3.28 as=0.42 ps=3.28 w=3 l=0.6
X55 VGND a_505_1193# a_2361_1095# VGND sky130_fd_pr__nfet_g5v0d10v5 ad=0.42 pd=3.28 as=0.42 ps=3.28 w=3 l=0.6
X56 a_3417_1193# a_505_1193# VCC_IO VCC_IO sky130_fd_pr__pfet_g5v0d10v5 ad=0.7 pd=5.28 as=0.7 ps=5.28 w=5 l=0.6
X57 VGND a_176_279# a_987_279# VGND sky130_fd_pr__nfet_g5v0d10v5 ad=0.795 pd=6.53 as=0.42 ps=3.28 w=3 l=0.6
X58 a_3417_1193# a_505_1193# VCC_IO VCC_IO sky130_fd_pr__pfet_g5v0d10v5 ad=0.7 pd=5.28 as=0.7 ps=5.28 w=5 l=0.6
X59 VGND a_2361_1095# DRVLO_H_N VGND sky130_fd_pr__nfet_g5v0d10v5 ad=0.42 pd=3.28 as=0.42 ps=3.28 w=3 l=0.6
X60 a_2361_1095# a_505_1193# VGND VGND sky130_fd_pr__nfet_g5v0d10v5 ad=0.42 pd=3.28 as=0.42 ps=3.28 w=3 l=0.6
X61 a_987_279# a_176_279# VGND VGND sky130_fd_pr__nfet_g5v0d10v5 ad=0.42 pd=3.28 as=0.42 ps=3.28 w=3 l=0.6
X62 a_1628_279# a_638_279# a_947_1193# VGND sky130_fd_pr__nfet_g5v0d10v5 ad=0.795 pd=6.53 as=0.42 ps=3.28 w=3 l=0.6
.ends

.subckt sky130_fd_io__com_opath_datoev2 OE_H DRVLO_H_N VCC_IO HLD_I_OVR_H a_5565_99#
+ OUT OE_N sky130_fd_io__com_cclat_0/PD_DIS_H VPWR_KA DRVHI_H li_5565_99# sky130_fd_io__gpio_dat_ls_1v2_0/SET_H
+ VGND OD_H
Xsky130_fd_io__gpio_dat_ls_1v2_0 sky130_fd_io__com_cclat_0/PU_DIS_H VGND sky130_fd_io__gpio_dat_ls_1v2_0/SET_H
+ HLD_I_OVR_H VCC_IO VGND sky130_fd_io__com_cclat_0/PD_DIS_H VPWR_KA OUT sky130_fd_io__gpio_dat_ls_1v2
Xsky130_fd_io__gpio_dat_lsv2_0 OE_H VGND OD_H HLD_I_OVR_H VCC_IO VGND sky130_fd_io__com_cclat_0/OE_H_N
+ VPWR_KA OE_N a_28_1762# sky130_fd_io__gpio_dat_lsv2
Xsky130_fd_io__com_cclat_0 sky130_fd_io__com_cclat_0/PU_DIS_H sky130_fd_io__com_cclat_0/PD_DIS_H
+ VGND sky130_fd_io__com_cclat_0/OE_H_N DRVLO_H_N DRVHI_H VCC_IO sky130_fd_io__com_cclat
.ends

.subckt sky130_fd_io__com_pdpredrvr_weakv2 DRVLO_H_N PDEN_H_N VGND_IO VCC_IO PD_H
X0 PD_H DRVLO_H_N a_73_866# VCC_IO sky130_fd_pr__pfet_g5v0d10v5 ad=0.795 pd=6.53 as=0.42 ps=3.28 w=3 l=0.6
X1 a_73_866# PDEN_H_N VCC_IO VCC_IO sky130_fd_pr__pfet_g5v0d10v5 ad=0.42 pd=3.28 as=0.42 ps=3.28 w=3 l=0.6
X2 PD_H PDEN_H_N VGND_IO VGND_IO sky130_fd_pr__nfet_g5v0d10v5 ad=0.42 pd=3.28 as=0.795 ps=6.53 w=3 l=0.6
X3 VGND_IO DRVLO_H_N PD_H VGND_IO sky130_fd_pr__nfet_g5v0d10v5 ad=0.795 pd=6.53 as=0.42 ps=3.28 w=3 l=0.6
X4 VCC_IO PDEN_H_N a_73_866# VCC_IO sky130_fd_pr__pfet_g5v0d10v5 ad=0.42 pd=3.28 as=0.795 ps=6.53 w=3 l=0.6
.ends

.subckt sky130_fd_io__gpiov2_octl_mux SEL_H_N A_H Y_H B_H SEL_H a_1266_1185# w_1191_2415#
X0 Y_H SEL_H A_H a_1266_1185# sky130_fd_pr__nfet_g5v0d10v5 ad=0.42 pd=3.28 as=0.795 ps=6.53 w=3 l=0.5
X1 A_H SEL_H_N Y_H w_1191_2415# sky130_fd_pr__pfet_g5v0d10v5 ad=0.795 pd=6.53 as=0.42 ps=3.28 w=3 l=0.5
X2 Y_H SEL_H B_H w_1191_2415# sky130_fd_pr__pfet_g5v0d10v5 ad=0.42 pd=3.28 as=0.795 ps=6.53 w=3 l=0.5
X3 B_H SEL_H_N Y_H a_1266_1185# sky130_fd_pr__nfet_g5v0d10v5 ad=0.795 pd=6.53 as=0.42 ps=3.28 w=3 l=0.5
.ends

.subckt sky130_fd_io__gpiov2_pdpredrvr_strong sky130_fd_io__gpiov2_octl_mux_0/SEL_H
+ sky130_fd_io__gpiov2_octl_mux_0/B_H sky130_fd_io__gpiov2_octl_mux_0/SEL_H_N sky130_fd_io__gpiov2_octl_mux_0/w_1191_2415#
+ sky130_fd_io__gpiov2_octl_mux_0/A_H sky130_fd_io__gpiov2_octl_mux_0/Y_H VSUBS
Xsky130_fd_io__gpiov2_octl_mux_0 sky130_fd_io__gpiov2_octl_mux_0/SEL_H_N sky130_fd_io__gpiov2_octl_mux_0/A_H
+ sky130_fd_io__gpiov2_octl_mux_0/Y_H sky130_fd_io__gpiov2_octl_mux_0/B_H sky130_fd_io__gpiov2_octl_mux_0/SEL_H
+ VSUBS sky130_fd_io__gpiov2_octl_mux_0/w_1191_2415# sky130_fd_io__gpiov2_octl_mux
.ends

.subckt sky130_fd_io__feascom_pupredrvr_nbiasv2 EN_H_N EN_H VGND_IO NBIAS DRVHI_H
+ PUEN_H VCC_IO PU_H_N a_261_220# a_2821_220# a_2874_118# a_1772_220#
X0 VCC_IO a_250_1898# a_1507_1397# VCC_IO sky130_fd_pr__pfet_g5v0d10v5 ad=0.14 pd=1.28 as=0.14 ps=1.28 w=1 l=0.8
X1 VGND_IO a_261_220# a_261_220# VGND_IO sky130_fd_pr__nfet_g5v0d10v5 ad=0.42 pd=3.28 as=0.42 ps=3.28 w=3 l=0.5
X2 a_1507_1397# a_250_1898# VCC_IO VCC_IO sky130_fd_pr__pfet_g5v0d10v5 ad=0.14 pd=1.28 as=0.14 ps=1.28 w=1 l=0.8
X3 a_261_220# a_261_220# VGND_IO VGND_IO sky130_fd_pr__nfet_g5v0d10v5 ad=0.42 pd=3.28 as=0.795 ps=6.53 w=3 l=0.5
X4 a_1672_194# a_207_1014# VGND_IO VGND_IO sky130_fd_pr__nfet_g5v0d10v5 ad=0.795 pd=6.53 as=0.42 ps=3.28 w=3 l=0.5
X5 NBIAS a_250_1898# VCC_IO VCC_IO sky130_fd_pr__pfet_g5v0d10v5 ad=0.14 pd=1.28 as=0.1925 ps=1.385 w=1 l=0.8
X6 a_250_1898# a_562_1898# VCC_IO VCC_IO sky130_fd_pr__pfet_g5v0d10v5 ad=0.42 pd=3.28 as=0.795 ps=6.53 w=3 l=0.5
X7 VGND_IO a_1672_194# a_1772_220# VGND_IO sky130_fd_pr__nfet_g5v0d10v5 ad=0.42 pd=3.28 as=0.42 ps=3.28 w=3 l=0.5
X8 VCC_IO a_250_1898# a_2874_118# VCC_IO sky130_fd_pr__pfet_g5v0d10v5 ad=1.325 pd=10.53 as=0.7 ps=5.28 w=5 l=0.5
X9 NBIAS NBIAS a_261_220# VGND_IO sky130_fd_pr__nfet_g5v0d10v5 ad=0.42 pd=3.28 as=0.795 ps=6.53 w=3 l=0.5
X10 VGND_IO a_1672_194# a_1772_220# VGND_IO sky130_fd_pr__nfet_g5v0d10v5 ad=0.42 pd=3.28 as=0.42 ps=3.28 w=3 l=0.5
R0 a_562_1898# m1_2838_1831# sky130_fd_pr__res_generic_m1 w=0.26 l=10m
R1 m1_1014_127# NBIAS sky130_fd_pr__res_generic_m1 w=0.26 l=10m
X11 VCC_IO DRVHI_H a_562_1898# VCC_IO sky130_fd_pr__pfet_g5v0d10v5 ad=0.185 pd=1.515 as=0.14 ps=1.28 w=1 l=0.5
R2 m1_1014_800# NBIAS sky130_fd_pr__res_generic_m1 w=0.26 l=10m
X12 a_261_220# a_261_220# VGND_IO VGND_IO sky130_fd_pr__nfet_g5v0d10v5 ad=0.42 pd=3.28 as=0.42 ps=3.28 w=3 l=0.5
R3 m1_575_1252# EN_H sky130_fd_pr__res_generic_m1 w=0.26 l=10m
X13 a_250_1898# DRVHI_H VCC_IO VCC_IO sky130_fd_pr__pfet_g5v0d10v5 ad=0.14 pd=1.28 as=0.265 ps=2.53 w=1 l=0.5
X14 VGND_IO DRVHI_H a_207_1014# VGND_IO sky130_fd_pr__nfet_g5v0d10v5 ad=0.32375 pd=2.015 as=0.265 ps=2.53 w=1 l=0.6
X15 VGND_IO a_207_1014# NBIAS VGND_IO sky130_fd_pr__nfet_g5v0d10v5 ad=0.42 pd=3.28 as=0.42 ps=3.28 w=3 l=0.5
R4 m1_2838_1794# a_620_1263# sky130_fd_pr__res_generic_m1 w=0.26 l=10m
R5 m1_612_1252# a_620_1263# sky130_fd_pr__res_generic_m1 w=0.26 l=10m
X16 VGND_IO a_250_1898# a_1004_990# VGND_IO sky130_fd_pr__nfet_g5v0d10v5 ad=0.0588 pd=0.7 as=0.1113 ps=1.37 w=0.42 l=4
X17 NBIAS NBIAS a_261_220# VGND_IO sky130_fd_pr__nfet_g5v0d10v5 ad=0.42 pd=3.28 as=0.42 ps=3.28 w=3 l=0.5
X18 VCC_IO a_250_1898# NBIAS VCC_IO sky130_fd_pr__pfet_g5v0d10v5 ad=0.14 pd=1.28 as=0.14 ps=1.28 w=1 l=0.8
X19 a_2874_118# a_250_1898# VCC_IO VCC_IO sky130_fd_pr__pfet_g5v0d10v5 ad=0.7 pd=5.28 as=1.0375 ps=5.515 w=5 l=0.5
X20 a_583_914# EN_H VGND_IO VGND_IO sky130_fd_pr__nfet_g5v0d10v5 ad=0.2025 pd=1.77 as=0.32375 ps=2.015 w=1.5 l=0.5
X21 a_2821_220# a_2874_118# a_2874_118# VGND_IO sky130_fd_pr__nfet_g5v0d10v5 ad=0.42 pd=3.28 as=0.42 ps=3.28 w=3 l=0.5
X22 a_1772_220# a_1672_194# VGND_IO VGND_IO sky130_fd_pr__nfet_g5v0d10v5 ad=0.42 pd=3.28 as=0.42 ps=3.28 w=3 l=0.5
R6 m1_1409_1332# NBIAS sky130_fd_pr__res_generic_m1 w=0.23 l=10m
X23 NBIAS a_250_1898# VCC_IO VCC_IO sky130_fd_pr__pfet_g5v0d10v5 ad=0.14 pd=1.28 as=0.14 ps=1.28 w=1 l=0.8
R7 m1_1608_646# a_1772_220# sky130_fd_pr__res_generic_m1 w=0.23 l=10m
X24 a_207_1014# DRVHI_H VCC_IO VCC_IO sky130_fd_pr__pfet_g5v0d10v5 ad=0.14 pd=1.28 as=0.265 ps=2.53 w=1 l=0.5
X25 a_250_1898# a_562_1898# VCC_IO VCC_IO sky130_fd_pr__pfet_g5v0d10v5 ad=0.42 pd=3.28 as=0.42 ps=3.28 w=3 l=0.5
X26 a_261_220# NBIAS NBIAS VGND_IO sky130_fd_pr__nfet_g5v0d10v5 ad=0.42 pd=3.28 as=0.42 ps=3.28 w=3 l=0.5
X27 NBIAS EN_H_N VGND_IO VGND_IO sky130_fd_pr__nfet_g5v0d10v5 ad=0.42 pd=3.28 as=0.42 ps=3.28 w=3 l=0.5
X28 VCC_IO a_250_1898# a_1507_1397# VCC_IO sky130_fd_pr__pfet_g5v0d10v5 ad=0.265 pd=2.53 as=0.14 ps=1.28 w=1 l=0.8
X29 a_2821_220# a_2821_220# a_1672_194# VGND_IO sky130_fd_pr__nfet_g5v0d10v5 ad=0.795 pd=6.53 as=0.42 ps=3.28 w=3 l=0.5
X30 VCC_IO a_562_1898# a_250_1898# VCC_IO sky130_fd_pr__pfet_g5v0d10v5 ad=1.0375 pd=5.515 as=0.42 ps=3.28 w=3 l=0.5
X31 a_1772_220# a_1672_194# VGND_IO VGND_IO sky130_fd_pr__nfet_g5v0d10v5 ad=0.42 pd=3.28 as=0.42 ps=3.28 w=3 l=0.5
R8 m1_2596_1928# a_2421_2014# sky130_fd_pr__res_generic_m1 w=0.26 l=10m
X32 a_1507_1397# a_250_1898# VCC_IO VCC_IO sky130_fd_pr__pfet_g5v0d10v5 ad=0.14 pd=1.28 as=0.14 ps=1.28 w=1 l=0.8
R9 m1_2596_1928# a_250_1898# sky130_fd_pr__res_generic_m1 w=0.26 l=10m
X33 VCC_IO EN_H a_250_1898# VCC_IO sky130_fd_pr__pfet_g5v0d10v5 ad=0.14 pd=1.28 as=0.14 ps=1.28 w=1 l=0.5
X34 a_562_1898# PUEN_H VCC_IO VCC_IO sky130_fd_pr__pfet_g5v0d10v5 ad=0.14 pd=1.28 as=0.14 ps=1.28 w=1 l=0.5
X35 a_2421_2014# PU_H_N VCC_IO VCC_IO sky130_fd_pr__pfet_g5v0d10v5 ad=0.1113 pd=1.37 as=0.185 ps=1.515 w=0.42 l=8
R10 m1_702_1715# PU_H_N sky130_fd_pr__res_generic_m1 w=0.23 l=10m
R11 m1_1409_1332# a_1507_1397# sky130_fd_pr__res_generic_m1 w=0.23 l=10m
X36 VCC_IO a_250_1898# NBIAS VCC_IO sky130_fd_pr__pfet_g5v0d10v5 ad=0.14 pd=1.28 as=0.14 ps=1.28 w=1 l=0.8
X37 a_737_914# a_620_1263# a_583_914# VGND_IO sky130_fd_pr__nfet_g5v0d10v5 ad=0.2025 pd=1.77 as=0.2025 ps=1.77 w=1.5 l=0.5
X38 a_261_220# NBIAS NBIAS VGND_IO sky130_fd_pr__nfet_g5v0d10v5 ad=0.795 pd=6.53 as=0.42 ps=3.28 w=3 l=0.5
X39 VGND_IO a_261_220# a_261_220# VGND_IO sky130_fd_pr__nfet_g5v0d10v5 ad=0.42 pd=3.28 as=0.42 ps=3.28 w=3 l=0.5
R12 m1_1014_800# a_1004_990# sky130_fd_pr__res_generic_m1 w=0.26 l=10m
R13 m1_1046_126# a_261_220# sky130_fd_pr__res_generic_m1 w=0.26 l=10m
X40 VCC_IO a_562_1898# a_250_1898# VCC_IO sky130_fd_pr__pfet_g5v0d10v5 ad=0.42 pd=3.28 as=0.42 ps=3.28 w=3 l=0.5
R14 a_620_1263# m1_702_1715# sky130_fd_pr__res_generic_m1 w=0.23 l=10m
X41 a_250_1898# DRVHI_H a_737_914# VGND_IO sky130_fd_pr__nfet_g5v0d10v5 ad=0.3975 pd=3.53 as=0.2025 ps=1.77 w=1.5 l=0.5
R15 m1_1608_646# a_261_220# sky130_fd_pr__res_generic_m1 w=0.23 l=10m
X42 a_1672_194# a_2821_220# a_2821_220# VGND_IO sky130_fd_pr__nfet_g5v0d10v5 ad=0.42 pd=3.28 as=0.42 ps=3.28 w=3 l=0.5
X43 a_562_1898# a_620_1263# a_620_1263# VCC_IO sky130_fd_pr__pfet_g5v0d10v5 ad=0.795 pd=6.53 as=0.795 ps=6.53 w=3 l=0.5
X44 a_1672_194# VCC_IO VGND_IO VGND_IO sky130_fd_pr__nfet_g5v0d10v5 ad=0.1113 pd=1.37 as=0.0588 ps=0.7 w=0.42 l=8
X45 VCC_IO DRVHI_H a_207_1014# VCC_IO sky130_fd_pr__pfet_g5v0d10v5 ad=0.1925 pd=1.385 as=0.14 ps=1.28 w=1 l=0.5
X46 a_2874_118# a_2874_118# a_2821_220# VGND_IO sky130_fd_pr__nfet_g5v0d10v5 ad=0.42 pd=3.28 as=0.795 ps=6.53 w=3 l=0.5
.ends

.subckt sky130_fd_io__gpiov2_pupredrvr_strong_nd2 EN_FAST[0] EN_FAST[1] EN_FAST[2]
+ EN_FAST[3] VGND_IO VCC_IO PU_H_N DRVHI_H PUEN_H a_158_632#
X0 VCC_IO DRVHI_H PU_H_N VCC_IO sky130_fd_pr__pfet_g5v0d10v5 ad=0.7 pd=5.28 as=1.325 ps=10.53 w=5 l=0.6
X1 a_311_632# DRVHI_H a_158_632# VGND_IO sky130_fd_pr__nfet_g5v0d10v5 ad=0.1575 pd=1.71 as=0.3975 ps=3.53 w=1.5 l=0.5
X2 VGND_IO EN_FAST[3] a_311_632# VGND_IO sky130_fd_pr__nfet_g5v0d10v5 ad=0.21 pd=1.78 as=0.1575 ps=1.71 w=1.5 l=1
R0 PU_H_N m1_1184_866# sky130_fd_pr__res_generic_m1 w=0.26 l=10m
X3 PU_H_N DRVHI_H VCC_IO VCC_IO sky130_fd_pr__pfet_g5v0d10v5 ad=0.7 pd=5.28 as=0.7 ps=5.28 w=5 l=0.6
X4 PU_H_N PUEN_H VCC_IO VCC_IO sky130_fd_pr__pfet_g5v0d10v5 ad=1.325 pd=10.53 as=0.7 ps=5.28 w=5 l=0.6
R1 m1_1184_866# a_158_632# sky130_fd_pr__res_generic_m1 w=0.26 l=10m
X5 VCC_IO DRVHI_H PU_H_N VCC_IO sky130_fd_pr__pfet_g5v0d10v5 ad=0.7 pd=5.28 as=0.7 ps=5.28 w=5 l=0.6
X6 a_158_632# DRVHI_H a_809_1060# VGND_IO sky130_fd_pr__nfet_g5v0d10v5 ad=0.3975 pd=3.53 as=0.165 ps=1.72 w=1.5 l=0.5
X7 a_1008_2434# PU_H_N sky130_fd_pr__res_generic_po w=0.33 l=4
X8 a_809_632# EN_FAST[2] VGND_IO VGND_IO sky130_fd_pr__nfet_g5v0d10v5 ad=0.165 pd=1.72 as=0.21 ps=1.78 w=1.5 l=1
X9 a_158_632# DRVHI_H a_809_632# VGND_IO sky130_fd_pr__nfet_g5v0d10v5 ad=0.3975 pd=3.53 as=0.165 ps=1.72 w=1.5 l=0.5
X10 a_1008_2434# a_158_632# sky130_fd_pr__res_generic_po w=0.33 l=11
X11 a_311_1060# DRVHI_H a_158_632# VGND_IO sky130_fd_pr__nfet_g5v0d10v5 ad=0.1575 pd=1.71 as=0.3975 ps=3.53 w=1.5 l=0.5
X12 VGND_IO EN_FAST[0] a_311_1060# VGND_IO sky130_fd_pr__nfet_g5v0d10v5 ad=0.21 pd=1.78 as=0.1575 ps=1.71 w=1.5 l=1
X13 PU_H_N DRVHI_H a_158_109# VGND_IO sky130_fd_pr__nfet_g5v0d10v5 ad=0.1113 pd=1.37 as=0.1113 ps=1.37 w=0.42 l=4
X14 VGND_IO PUEN_H a_158_109# VGND_IO sky130_fd_pr__nfet_g5v0d10v5 ad=0.1113 pd=1.37 as=0.1113 ps=1.37 w=0.42 l=4
X15 a_809_1060# EN_FAST[1] VGND_IO VGND_IO sky130_fd_pr__nfet_g5v0d10v5 ad=0.165 pd=1.72 as=0.21 ps=1.78 w=1.5 l=1
.ends

.subckt sky130_fd_io__gpiov2_pupredrvr_strong_nd2_a EN_FAST[0] EN_FAST[1] EN_FAST[2]
+ EN_FAST[3] VGND_IO VCC_IO PU_H_N DRVHI_H PUEN_H a_353_606# a_609_606#
X0 VCC_IO DRVHI_H PU_H_N VCC_IO sky130_fd_pr__pfet_g5v0d10v5 ad=0.7 pd=5.28 as=1.325 ps=10.53 w=5 l=0.6
X1 a_311_632# DRVHI_H a_158_632# VGND_IO sky130_fd_pr__nfet_g5v0d10v5 ad=0.1575 pd=1.71 as=0.3975 ps=3.53 w=1.5 l=0.5
X2 VGND_IO a_353_606# a_311_632# VGND_IO sky130_fd_pr__nfet_g5v0d10v5 ad=0.21 pd=1.78 as=0.1575 ps=1.71 w=1.5 l=1
R0 PU_H_N m1_1184_866# sky130_fd_pr__res_generic_m1 w=0.26 l=10m
X3 VGND_IO PUEN_H a_158_199# VGND_IO sky130_fd_pr__nfet_g5v0d10v5 ad=0.1113 pd=1.37 as=0.1113 ps=1.37 w=0.42 l=4
X4 PU_H_N DRVHI_H VCC_IO VCC_IO sky130_fd_pr__pfet_g5v0d10v5 ad=0.7 pd=5.28 as=0.7 ps=5.28 w=5 l=0.6
X5 PU_H_N PUEN_H VCC_IO VCC_IO sky130_fd_pr__pfet_g5v0d10v5 ad=1.325 pd=10.53 as=0.7 ps=5.28 w=5 l=0.6
R1 m1_1184_866# a_158_632# sky130_fd_pr__res_generic_m1 w=0.26 l=10m
X6 VCC_IO DRVHI_H PU_H_N VCC_IO sky130_fd_pr__pfet_g5v0d10v5 ad=0.7 pd=5.28 as=0.7 ps=5.28 w=5 l=0.6
X7 a_158_632# DRVHI_H a_809_1060# VGND_IO sky130_fd_pr__nfet_g5v0d10v5 ad=0.3975 pd=3.53 as=0.165 ps=1.72 w=1.5 l=0.5
X8 a_1008_2434# PU_H_N sky130_fd_pr__res_generic_po w=0.33 l=4
X9 a_809_632# a_609_606# VGND_IO VGND_IO sky130_fd_pr__nfet_g5v0d10v5 ad=0.165 pd=1.72 as=0.21 ps=1.78 w=1.5 l=1
X10 a_158_632# DRVHI_H a_809_632# VGND_IO sky130_fd_pr__nfet_g5v0d10v5 ad=0.3975 pd=3.53 as=0.165 ps=1.72 w=1.5 l=0.5
X11 a_1008_2434# a_158_632# sky130_fd_pr__res_generic_po w=0.33 l=11
X12 a_311_1060# DRVHI_H a_158_632# VGND_IO sky130_fd_pr__nfet_g5v0d10v5 ad=0.1575 pd=1.71 as=0.3975 ps=3.53 w=1.5 l=0.5
X13 VGND_IO EN_FAST[0] a_311_1060# VGND_IO sky130_fd_pr__nfet_g5v0d10v5 ad=0.21 pd=1.78 as=0.1575 ps=1.71 w=1.5 l=1
X14 PU_H_N DRVHI_H a_158_199# VGND_IO sky130_fd_pr__nfet_g5v0d10v5 ad=0.1113 pd=1.37 as=0.1113 ps=1.37 w=0.42 l=4
X15 a_809_1060# EN_FAST[1] VGND_IO VGND_IO sky130_fd_pr__nfet_g5v0d10v5 ad=0.165 pd=1.72 as=0.21 ps=1.78 w=1.5 l=1
.ends

.subckt sky130_fd_io__gpio_pupredrvr_strongv2 VCC_IO PU_H_N[3] PUEN_H PU_H_N[2] SLOW_H_N
+ sky130_fd_io__feascom_pupredrvr_nbiasv2_0/a_1772_220# sky130_fd_io__gpiov2_pupredrvr_strong_nd2_0/a_158_632#
+ sky130_fd_io__feascom_pupredrvr_nbiasv2_0/NBIAS sky130_fd_io__feascom_pupredrvr_nbiasv2_0/a_261_220#
+ sky130_fd_io__feascom_pupredrvr_nbiasv2_0/a_2821_220# DRVHI_H sky130_fd_io__feascom_pupredrvr_nbiasv2_0/a_2874_118#
+ VSUBS
Xsky130_fd_io__feascom_pupredrvr_nbiasv2_0 sky130_fd_io__feascom_pupredrvr_nbiasv2_0/EN_H_N
+ sky130_fd_io__feascom_pupredrvr_nbiasv2_0/EN_H VSUBS sky130_fd_io__feascom_pupredrvr_nbiasv2_0/NBIAS
+ DRVHI_H PUEN_H VCC_IO PU_H_N[2] sky130_fd_io__feascom_pupredrvr_nbiasv2_0/a_261_220#
+ sky130_fd_io__feascom_pupredrvr_nbiasv2_0/a_2821_220# sky130_fd_io__feascom_pupredrvr_nbiasv2_0/a_2874_118#
+ sky130_fd_io__feascom_pupredrvr_nbiasv2_0/a_1772_220# sky130_fd_io__feascom_pupredrvr_nbiasv2
Xsky130_fd_io__gpiov2_pupredrvr_strong_nd2_0 sky130_fd_io__gpiov2_pupredrvr_strong_nd2_0/EN_FAST[0]
+ sky130_fd_io__gpiov2_pupredrvr_strong_nd2_0/EN_FAST[1] sky130_fd_io__gpiov2_pupredrvr_strong_nd2_0/EN_FAST[2]
+ sky130_fd_io__gpiov2_pupredrvr_strong_nd2_0/EN_FAST[3] VSUBS VCC_IO PU_H_N[3] DRVHI_H
+ PUEN_H sky130_fd_io__gpiov2_pupredrvr_strong_nd2_0/a_158_632# sky130_fd_io__gpiov2_pupredrvr_strong_nd2
Xsky130_fd_io__gpiov2_pupredrvr_strong_nd2_a_0 sky130_fd_io__gpiov2_pupredrvr_strong_nd2_a_0/EN_FAST[3]
+ sky130_fd_io__gpiov2_pupredrvr_strong_nd2_a_0/EN_FAST[3] sky130_fd_io__gpiov2_pupredrvr_strong_nd2_a_0/EN_FAST[3]
+ sky130_fd_io__gpiov2_pupredrvr_strong_nd2_a_0/EN_FAST[3] VSUBS VCC_IO PU_H_N[2]
+ DRVHI_H PUEN_H sky130_fd_io__gpiov2_pupredrvr_strong_nd2_a_0/EN_FAST[3] sky130_fd_io__gpiov2_pupredrvr_strong_nd2_a_0/EN_FAST[3]
+ sky130_fd_io__gpiov2_pupredrvr_strong_nd2_a
R0 m1_4655_1468# sky130_fd_io__feascom_pupredrvr_nbiasv2_0/NBIAS sky130_fd_pr__res_generic_m1 w=0.26 l=10m
X0 VCC_IO PUEN_H sky130_fd_io__feascom_pupredrvr_nbiasv2_0/EN_H_N VCC_IO sky130_fd_pr__pfet_g5v0d10v5 ad=0.42 pd=3.28 as=0.42 ps=3.28 w=3 l=0.6
R1 m1_6555_1273# VSUBS sky130_fd_pr__res_generic_m1 w=0.65 l=10m
R2 m1_6556_1365# sky130_fd_io__gpiov2_pupredrvr_strong_nd2_0/EN_FAST[0] sky130_fd_pr__res_generic_m1 w=0.65 l=10m
X1 sky130_fd_io__feascom_pupredrvr_nbiasv2_0/EN_H_N SLOW_H_N VCC_IO VCC_IO sky130_fd_pr__pfet_g5v0d10v5 ad=0.42 pd=3.28 as=0.795 ps=6.53 w=3 l=0.6
R3 sky130_fd_io__gpiov2_pupredrvr_strong_nd2_0/EN_FAST[1] m1_6299_1273# sky130_fd_pr__res_generic_m1 w=0.65 l=10m
R4 VSUBS m1_6266_605# sky130_fd_pr__res_generic_m1 w=0.65 l=10m
R5 m1_5759_509# sky130_fd_io__gpiov2_pupredrvr_strong_nd2_0/EN_FAST[3] sky130_fd_pr__res_generic_m1 w=0.26 l=10m
R6 m1_4777_1326# sky130_fd_io__gpiov2_pupredrvr_strong_nd2_a_0/EN_FAST[3] sky130_fd_pr__res_generic_m1 w=0.26 l=10m
R7 m1_5786_421# sky130_fd_io__feascom_pupredrvr_nbiasv2_0/NBIAS sky130_fd_pr__res_generic_m1 w=0.26 l=10m
R8 m1_4655_1468# sky130_fd_io__gpiov2_pupredrvr_strong_nd2_a_0/EN_FAST[3] sky130_fd_pr__res_generic_m1 w=0.26 l=10m
R9 m1_6266_568# sky130_fd_io__gpiov2_pupredrvr_strong_nd2_0/EN_FAST[2] sky130_fd_pr__res_generic_m1 w=0.65 l=10m
R10 sky130_fd_io__gpiov2_pupredrvr_strong_nd2_0/EN_FAST[3] m1_5786_421# sky130_fd_pr__res_generic_m1 w=0.26 l=10m
X2 sky130_fd_io__feascom_pupredrvr_nbiasv2_0/EN_H sky130_fd_io__feascom_pupredrvr_nbiasv2_0/EN_H_N VCC_IO VCC_IO sky130_fd_pr__pfet_g5v0d10v5 ad=0.795 pd=6.53 as=0.42 ps=3.28 w=3 l=0.6
R11 sky130_fd_io__gpiov2_pupredrvr_strong_nd2_0/EN_FAST[3] m1_6300_1402# sky130_fd_pr__res_generic_m1 w=0.65 l=10m
R12 sky130_fd_io__gpiov2_pupredrvr_strong_nd2_0/EN_FAST[2] m1_6265_477# sky130_fd_pr__res_generic_m1 w=0.65 l=10m
R13 m1_5722_509# sky130_fd_io__feascom_pupredrvr_nbiasv2_0/EN_H sky130_fd_pr__res_generic_m1 w=0.26 l=10m
R14 m1_6300_1365# sky130_fd_io__gpiov2_pupredrvr_strong_nd2_0/EN_FAST[1] sky130_fd_pr__res_generic_m1 w=0.65 l=10m
R15 m1_6299_1273# VSUBS sky130_fd_pr__res_generic_m1 w=0.65 l=10m
R16 sky130_fd_io__gpiov2_pupredrvr_strong_nd2_0/EN_FAST[0] m1_6555_1273# sky130_fd_pr__res_generic_m1 w=0.65 l=10m
R17 m1_6265_477# sky130_fd_io__gpiov2_pupredrvr_strong_nd2_0/EN_FAST[3] sky130_fd_pr__res_generic_m1 w=0.65 l=10m
X3 VSUBS PUEN_H a_483_1179# VSUBS sky130_fd_pr__nfet_g5v0d10v5 ad=0.14 pd=1.28 as=0.14 ps=1.28 w=1 l=0.6
X4 a_483_1179# SLOW_H_N sky130_fd_io__feascom_pupredrvr_nbiasv2_0/EN_H_N VSUBS sky130_fd_pr__nfet_g5v0d10v5 ad=0.14 pd=1.28 as=0.265 ps=2.53 w=1 l=0.6
X5 sky130_fd_io__feascom_pupredrvr_nbiasv2_0/EN_H sky130_fd_io__feascom_pupredrvr_nbiasv2_0/EN_H_N VSUBS VSUBS sky130_fd_pr__nfet_g5v0d10v5 ad=0.265 pd=2.53 as=0.14 ps=1.28 w=1 l=0.6
R18 m1_4740_1326# sky130_fd_io__feascom_pupredrvr_nbiasv2_0/EN_H sky130_fd_pr__res_generic_m1 w=0.26 l=10m
R19 sky130_fd_io__gpiov2_pupredrvr_strong_nd2_0/EN_FAST[3] m1_6556_1402# sky130_fd_pr__res_generic_m1 w=0.65 l=10m
.ends

.subckt sky130_fd_io__gpiov2_obpredrvr sky130_fd_io__gpio_pupredrvr_strongv2_0/SLOW_H_N
+ sky130_fd_io__com_pdpredrvr_weakv2_0/PDEN_H_N sky130_fd_io__gpio_pupredrvr_strongv2_0/PUEN_H
+ sky130_fd_io__gpio_pupredrvr_strongv2_0/sky130_fd_io__feascom_pupredrvr_nbiasv2_0/a_261_220#
+ sky130_fd_io__gpiov2_pdpredrvr_strong_0/sky130_fd_io__gpiov2_octl_mux_0/SEL_H_N
+ sky130_fd_io__com_pdpredrvr_weakv2_0/VCC_IO sky130_fd_io__gpio_pupredrvr_strongv2_0/sky130_fd_io__feascom_pupredrvr_nbiasv2_0/a_2821_220#
+ sky130_fd_io__gpio_pupredrvr_strongv2_0/sky130_fd_io__feascom_pupredrvr_nbiasv2_0/a_2874_118#
+ sky130_fd_io__gpiov2_pdpredrvr_strong_0/sky130_fd_io__gpiov2_octl_mux_0/A_H sky130_fd_io__gpiov2_pdpredrvr_strong_0/sky130_fd_io__gpiov2_octl_mux_0/Y_H
+ sky130_fd_io__gpiov2_pdpredrvr_strong_0/sky130_fd_io__gpiov2_octl_mux_0/SEL_H sky130_fd_io__com_pdpredrvr_weakv2_0/PD_H
+ sky130_fd_io__gpio_pupredrvr_strongv2_0/sky130_fd_io__feascom_pupredrvr_nbiasv2_0/a_1772_220#
+ sky130_fd_io__gpio_pupredrvr_strongv2_0/DRVHI_H sky130_fd_io__gpio_pupredrvr_strongv2_0/sky130_fd_io__gpiov2_pupredrvr_strong_nd2_0/a_158_632#
+ sky130_fd_io__gpio_pupredrvr_strongv2_0/PU_H_N[2] sky130_fd_io__gpiov2_pdpredrvr_strong_0/sky130_fd_io__gpiov2_octl_mux_0/w_1191_2415#
+ sky130_fd_io__gpio_pupredrvr_strongv2_0/PU_H_N[3] sky130_fd_io__com_pdpredrvr_weakv2_0/DRVLO_H_N
+ sky130_fd_io__gpiov2_pdpredrvr_strong_0/sky130_fd_io__gpiov2_octl_mux_0/B_H sky130_fd_io__gpio_pupredrvr_strongv2_0/sky130_fd_io__feascom_pupredrvr_nbiasv2_0/NBIAS
+ VSUBS sky130_fd_io__gpio_pupredrvr_strongv2_0/VCC_IO
Xsky130_fd_io__com_pdpredrvr_weakv2_0 sky130_fd_io__com_pdpredrvr_weakv2_0/DRVLO_H_N
+ sky130_fd_io__com_pdpredrvr_weakv2_0/PDEN_H_N VSUBS sky130_fd_io__com_pdpredrvr_weakv2_0/VCC_IO
+ sky130_fd_io__com_pdpredrvr_weakv2_0/PD_H sky130_fd_io__com_pdpredrvr_weakv2
Xsky130_fd_io__gpiov2_pdpredrvr_strong_0 sky130_fd_io__gpiov2_pdpredrvr_strong_0/sky130_fd_io__gpiov2_octl_mux_0/SEL_H
+ sky130_fd_io__gpiov2_pdpredrvr_strong_0/sky130_fd_io__gpiov2_octl_mux_0/B_H sky130_fd_io__gpiov2_pdpredrvr_strong_0/sky130_fd_io__gpiov2_octl_mux_0/SEL_H_N
+ sky130_fd_io__gpiov2_pdpredrvr_strong_0/sky130_fd_io__gpiov2_octl_mux_0/w_1191_2415#
+ sky130_fd_io__gpiov2_pdpredrvr_strong_0/sky130_fd_io__gpiov2_octl_mux_0/A_H sky130_fd_io__gpiov2_pdpredrvr_strong_0/sky130_fd_io__gpiov2_octl_mux_0/Y_H
+ VSUBS sky130_fd_io__gpiov2_pdpredrvr_strong
Xsky130_fd_io__gpio_pupredrvr_strongv2_0 sky130_fd_io__gpio_pupredrvr_strongv2_0/VCC_IO
+ sky130_fd_io__gpio_pupredrvr_strongv2_0/PU_H_N[3] sky130_fd_io__gpio_pupredrvr_strongv2_0/PUEN_H
+ sky130_fd_io__gpio_pupredrvr_strongv2_0/PU_H_N[2] sky130_fd_io__gpio_pupredrvr_strongv2_0/SLOW_H_N
+ sky130_fd_io__gpio_pupredrvr_strongv2_0/sky130_fd_io__feascom_pupredrvr_nbiasv2_0/a_1772_220#
+ sky130_fd_io__gpio_pupredrvr_strongv2_0/sky130_fd_io__gpiov2_pupredrvr_strong_nd2_0/a_158_632#
+ sky130_fd_io__gpio_pupredrvr_strongv2_0/sky130_fd_io__feascom_pupredrvr_nbiasv2_0/NBIAS
+ sky130_fd_io__gpio_pupredrvr_strongv2_0/sky130_fd_io__feascom_pupredrvr_nbiasv2_0/a_261_220#
+ sky130_fd_io__gpio_pupredrvr_strongv2_0/sky130_fd_io__feascom_pupredrvr_nbiasv2_0/a_2821_220#
+ sky130_fd_io__gpio_pupredrvr_strongv2_0/DRVHI_H sky130_fd_io__gpio_pupredrvr_strongv2_0/sky130_fd_io__feascom_pupredrvr_nbiasv2_0/a_2874_118#
+ VSUBS sky130_fd_io__gpio_pupredrvr_strongv2
.ends

.subckt sky130_fd_io__gpiov2_octl_dat VPWR_KA VGND SLOW HLD_I_OVR_H OD_H SLOW_H_N
+ DRVHI_H PU_H_N[2] PU_H_N[1] PU_H_N[0] PD_H[1] PD_H[0] PD_H[4] PD_H[3] PD_H[2] a_1106_3203#
+ a_3125_3203# a_4416_3253# sky130_fd_io__gpiov2_obpredrvr_0/sky130_fd_io__gpio_pupredrvr_strongv2_0/sky130_fd_io__feascom_pupredrvr_nbiasv2_0/NBIAS
+ sky130_fd_io__gpiov2_obpredrvr_0/sky130_fd_io__gpio_pupredrvr_strongv2_0/sky130_fd_io__feascom_pupredrvr_nbiasv2_0/a_261_220#
+ a_n433_1745# a_8354_4056# sky130_fd_io__gpiov2_obpredrvr_0/sky130_fd_io__gpio_pupredrvr_strongv2_0/sky130_fd_io__feascom_pupredrvr_nbiasv2_0/a_2821_220#
+ DM_H[0] sky130_fd_io__gpiov2_obpredrvr_0/sky130_fd_io__gpiov2_pdpredrvr_strong_0/sky130_fd_io__gpiov2_octl_mux_0/Y_H
+ DM_H[1] DM_H_N[0] DM_H_N[1] DM_H[2] DM_H_N[2] a_1415_3203# sky130_fd_io__gpiov2_obpredrvr_0/sky130_fd_io__gpio_pupredrvr_strongv2_0/sky130_fd_io__feascom_pupredrvr_nbiasv2_0/a_2874_118#
+ OE_N sky130_fd_io__com_opath_datoev2_0/li_5565_99# a_9656_1708# sky130_fd_io__gpiov2_obpredrvr_0/sky130_fd_io__gpio_pupredrvr_strongv2_0/sky130_fd_io__gpiov2_pupredrvr_strong_nd2_0/a_158_632#
+ HLD_I_H_N a_1528_3203# a_2205_3177# VGND_IO VPWR sky130_fd_io__gpiov2_obpredrvr_0/sky130_fd_io__gpio_pupredrvr_strongv2_0/sky130_fd_io__feascom_pupredrvr_nbiasv2_0/a_1772_220#
+ OUT VCC_IO PU_H_N[3]
Xsky130_fd_io__gpiov2_octl_0 sky130_fd_io__gpiov2_octl_0/PDEN_H_N[1] sky130_fd_io__gpiov2_octl_0/PDEN_H_N[0]
+ SLOW sky130_fd_io__gpiov2_octl_0/SLOW_H VCC_IO DM_H[1] DM_H[0] DM_H[2] DM_H_N[0]
+ DM_H_N[1] DM_H_N[2] sky130_fd_io__gpiov2_octl_0/PUEN_2OR1_H sky130_fd_io__gpiov2_obpredrvr_0/sky130_fd_io__gpiov2_pdpredrvr_strong_0/sky130_fd_io__gpiov2_octl_mux_0/SEL_H_N
+ DM_H[1] VCC_IO DM_H[0] VGND a_7799_1681# VCC_IO VPWR DM_H[2] a_13335_4479# VCC_IO
+ VCC_IO a_13335_4479# SLOW_H_N VGND sky130_fd_io__gpiov2_obpredrvr_0/sky130_fd_io__gpio_pupredrvr_strongv2_0/PUEN_H
+ HLD_I_H_N OD_H sky130_fd_io__gpiov2_octl
Xsky130_fd_io__com_opath_datoev2_0 sky130_fd_io__com_opath_datoev2_0/OE_H DRVLO_H_N
+ VCC_IO HLD_I_OVR_H VGND OUT OE_N sky130_fd_io__com_opath_datoev2_0/sky130_fd_io__com_cclat_0/PD_DIS_H
+ VPWR_KA DRVHI_H sky130_fd_io__com_opath_datoev2_0/li_5565_99# OD_H VGND OD_H sky130_fd_io__com_opath_datoev2
Xsky130_fd_io__gpiov2_obpredrvr_0 SLOW_H_N sky130_fd_io__gpiov2_octl_0/PDEN_H_N[0]
+ sky130_fd_io__gpiov2_obpredrvr_0/sky130_fd_io__gpio_pupredrvr_strongv2_0/PUEN_H
+ sky130_fd_io__gpiov2_obpredrvr_0/sky130_fd_io__gpio_pupredrvr_strongv2_0/sky130_fd_io__feascom_pupredrvr_nbiasv2_0/a_261_220#
+ sky130_fd_io__gpiov2_obpredrvr_0/sky130_fd_io__gpiov2_pdpredrvr_strong_0/sky130_fd_io__gpiov2_octl_mux_0/SEL_H_N
+ VCC_IO sky130_fd_io__gpiov2_obpredrvr_0/sky130_fd_io__gpio_pupredrvr_strongv2_0/sky130_fd_io__feascom_pupredrvr_nbiasv2_0/a_2821_220#
+ sky130_fd_io__gpiov2_obpredrvr_0/sky130_fd_io__gpio_pupredrvr_strongv2_0/sky130_fd_io__feascom_pupredrvr_nbiasv2_0/a_2874_118#
+ sky130_fd_io__gpiov2_obpredrvr_0/sky130_fd_io__gpiov2_pdpredrvr_strong_0/sky130_fd_io__gpiov2_octl_mux_0/A_H
+ sky130_fd_io__gpiov2_obpredrvr_0/sky130_fd_io__gpiov2_pdpredrvr_strong_0/sky130_fd_io__gpiov2_octl_mux_0/Y_H
+ sky130_fd_io__gpiov2_obpredrvr_0/sky130_fd_io__gpiov2_pdpredrvr_strong_0/sky130_fd_io__gpiov2_octl_mux_0/SEL_H
+ PD_H[0] sky130_fd_io__gpiov2_obpredrvr_0/sky130_fd_io__gpio_pupredrvr_strongv2_0/sky130_fd_io__feascom_pupredrvr_nbiasv2_0/a_1772_220#
+ DRVHI_H sky130_fd_io__gpiov2_obpredrvr_0/sky130_fd_io__gpio_pupredrvr_strongv2_0/sky130_fd_io__gpiov2_pupredrvr_strong_nd2_0/a_158_632#
+ PU_H_N[2] VCC_IO PU_H_N[3] DRVLO_H_N DRVLO_H_N sky130_fd_io__gpiov2_obpredrvr_0/sky130_fd_io__gpio_pupredrvr_strongv2_0/sky130_fd_io__feascom_pupredrvr_nbiasv2_0/NBIAS
+ VGND_IO VCC_IO sky130_fd_io__gpiov2_obpredrvr
X0 a_8354_4056# PD_H[4] a_8354_3203# VGND_IO sky130_fd_pr__nfet_g5v0d10v5 ad=0.1113 pd=1.37 as=0.1113 ps=1.37 w=0.42 l=4
X1 a_3125_3203# a_1415_3203# VCC_IO VCC_IO sky130_fd_pr__pfet_g5v0d10v5 ad=0.7 pd=5.28 as=0.7 ps=5.28 w=5 l=0.5
R0 a_7638_3476# m1_8994_2579# sky130_fd_pr__res_generic_m1 w=2.5 l=10m
X2 a_1528_3203# a_2205_3177# a_2205_3177# VCC_IO sky130_fd_pr__pfet_g5v0d10v5 ad=1.325 pd=10.53 as=0.7 ps=5.28 w=5 l=0.5
X3 a_1415_3203# a_1528_3203# a_1528_3203# VCC_IO sky130_fd_pr__pfet_g5v0d10v5 ad=0.7 pd=5.28 as=0.7 ps=5.28 w=5 l=0.5
X4 VCC_IO a_1415_3203# a_3125_3203# VCC_IO sky130_fd_pr__pfet_g5v0d10v5 ad=0.7 pd=5.28 as=0.7 ps=5.28 w=5 l=0.5
X5 VCC_IO DRVLO_H_N a_1159_3105# VCC_IO sky130_fd_pr__pfet_g5v0d10v5 ad=0.265 pd=2.53 as=0.14 ps=1.28 w=1 l=0.5
X6 VGND_IO a_7610_2597# a_1106_3203# VGND_IO sky130_fd_pr__nfet_g5v0d10v5 ad=0.14 pd=1.28 as=0.14 ps=1.28 w=1 l=1
X7 PU_H_N[0] a_7799_1681# VCC_IO VCC_IO sky130_fd_pr__pfet_g5v0d10v5 ad=1.325 pd=10.53 as=0.7 ps=5.28 w=5 l=0.6
X8 a_2205_3177# a_2205_3177# a_1528_3203# VCC_IO sky130_fd_pr__pfet_g5v0d10v5 ad=0.7 pd=5.28 as=0.7 ps=5.28 w=5 l=0.5
R1 a_10919_675# m1_10778_2585# sky130_fd_pr__res_generic_m1 w=0.26 l=10m
X9 a_1528_3203# a_1528_3203# a_1415_3203# VCC_IO sky130_fd_pr__pfet_g5v0d10v5 ad=0.7 pd=5.28 as=0.7 ps=5.28 w=5 l=0.5
X10 VGND_IO a_7799_1681# a_7743_1707# VGND_IO sky130_fd_pr__nfet_g5v0d10v5 ad=0.795 pd=6.53 as=0.42 ps=3.28 w=3 l=0.6
X11 VCC_IO a_4416_3253# a_4416_3253# VCC_IO sky130_fd_pr__pfet_g5v0d10v5 ad=0.7 pd=5.28 as=0.7 ps=5.28 w=5 l=0.5
X12 a_11758_843# sky130_fd_io__gpiov2_obpredrvr_0/sky130_fd_io__gpiov2_pdpredrvr_strong_0/sky130_fd_io__gpiov2_octl_mux_0/Y_H PD_H[3] VCC_IO sky130_fd_pr__pfet_g5v0d10v5 ad=0.0588 pd=0.7 as=0.0588 ps=0.7 w=0.42 l=2
X13 sky130_fd_io__gpiov2_obpredrvr_0/sky130_fd_io__gpiov2_pdpredrvr_strong_0/sky130_fd_io__gpiov2_octl_mux_0/SEL_H sky130_fd_io__gpiov2_obpredrvr_0/sky130_fd_io__gpiov2_pdpredrvr_strong_0/sky130_fd_io__gpiov2_octl_mux_0/SEL_H_N VCC_IO VCC_IO sky130_fd_pr__pfet_g5v0d10v5 ad=0.265 pd=2.53 as=0.265 ps=2.53 w=1 l=0.6
X14 VCC_IO DRVHI_H PU_H_N[1] VCC_IO sky130_fd_pr__pfet_g5v0d10v5 ad=0.42 pd=3.28 as=0.42 ps=3.28 w=3 l=0.5
X15 PD_H[3] sky130_fd_io__gpiov2_obpredrvr_0/sky130_fd_io__gpiov2_pdpredrvr_strong_0/sky130_fd_io__gpiov2_octl_mux_0/Y_H VGND_IO VGND_IO sky130_fd_pr__nfet_g5v0d10v5 ad=0.42 pd=3.28 as=0.42 ps=3.28 w=3 l=0.6
X16 a_1106_3203# a_1106_3203# a_4416_3253# VCC_IO sky130_fd_pr__pfet_g5v0d10v5 ad=0.7 pd=5.28 as=0.7 ps=5.28 w=5 l=0.5
X17 a_4416_3253# a_4416_3253# VCC_IO VCC_IO sky130_fd_pr__pfet_g5v0d10v5 ad=0.7 pd=5.28 as=0.7 ps=5.28 w=5 l=0.5
X18 VCC_IO a_n461_1863# a_9290_3718# VCC_IO sky130_fd_pr__pfet_g5v0d10v5 ad=0.42 pd=3.28 as=0.42 ps=3.28 w=3 l=0.5
X19 VGND PD_H[4] sky130_fd_io__gpiov2_obpredrvr_0/sky130_fd_io__gpiov2_pdpredrvr_strong_0/sky130_fd_io__gpiov2_octl_mux_0/A_H VGND sky130_fd_pr__nfet_g5v0d10v5 ad=0.1113 pd=1.37 as=0.1113 ps=1.37 w=0.42 l=0.5
X20 a_1415_3203# a_1159_3105# VCC_IO VCC_IO sky130_fd_pr__pfet_g5v0d10v5 ad=1.325 pd=10.53 as=0.7 ps=5.28 w=5 l=0.5
R2 m1_10510_2769# a_7462_4229# sky130_fd_pr__res_generic_m1 w=0.26 l=10m
X21 a_7161_3177# sky130_fd_io__gpiov2_octl_0/PDEN_H_N[1] VGND_IO VGND_IO sky130_fd_pr__nfet_g5v0d10v5 ad=0.14 pd=1.28 as=0.335 ps=2.67 w=1 l=0.6
X22 PD_H[3] sky130_fd_io__gpiov2_obpredrvr_0/sky130_fd_io__gpiov2_pdpredrvr_strong_0/sky130_fd_io__gpiov2_octl_mux_0/Y_H a_11053_559# VCC_IO sky130_fd_pr__pfet_g5v0d10v5 ad=0.0588 pd=0.7 as=0.1113 ps=1.37 w=0.42 l=0.5
X23 VCC_IO DRVHI_H PU_H_N[1] VCC_IO sky130_fd_pr__pfet_g5v0d10v5 ad=0.42 pd=3.28 as=0.795 ps=6.53 w=3 l=0.5
X24 a_n408_4001# sky130_fd_io__gpiov2_octl_0/SLOW_H a_n112_4027# VGND sky130_fd_pr__nfet_g5v0d10v5 ad=0.1855 pd=1.93 as=0.098 ps=0.98 w=0.7 l=0.6
X25 VCC_IO a_7610_2597# a_8026_3203# VCC_IO sky130_fd_pr__pfet_g5v0d10v5 ad=0.1113 pd=1.37 as=0.1113 ps=1.37 w=0.42 l=4
X26 a_7462_4229# a_7161_3177# VGND_IO VGND_IO sky130_fd_pr__nfet_g5v0d10v5 ad=0.265 pd=2.53 as=0.21 ps=1.42 w=1 l=0.6
X27 a_9290_3718# a_1106_3203# a_9882_3718# VCC_IO sky130_fd_pr__pfet_g5v0d10v5 ad=0.42 pd=3.28 as=0.795 ps=6.53 w=3 l=0.5
R3 m1_8330_3159# a_7610_2597# sky130_fd_pr__res_generic_m1 w=0.65 l=10m
R4 m1_10378_2704# m1_10351_2626# sky130_fd_pr__res_generic_m1 w=0.26 l=10m
X28 a_10564_1155# a_11085_1123# VCC_IO VCC_IO sky130_fd_pr__pfet_g5v0d10v5 ad=0.3975 pd=3.53 as=0.21 ps=1.78 w=1.5 l=0.5
X29 a_n408_1837# sky130_fd_io__gpiov2_octl_0/SLOW_H a_n112_1863# VGND sky130_fd_pr__nfet_g5v0d10v5 ad=0.1855 pd=1.93 as=0.098 ps=0.98 w=0.7 l=0.6
X30 a_8876_944# sky130_fd_io__gpiov2_octl_0/PDEN_H_N[1] VCC_IO VCC_IO sky130_fd_pr__pfet_g5v0d10v5 ad=0.42 pd=3.28 as=0.42 ps=3.28 w=3 l=0.5
X31 VCC_IO sky130_fd_io__gpiov2_octl_0/SLOW_H a_n408_1837# VCC_IO sky130_fd_pr__pfet_g5v0d10v5 ad=0.265 pd=2.53 as=0.14 ps=1.28 w=1 l=0.6
R5 m1_10312_2627# a_1106_3203# sky130_fd_pr__res_generic_m1 w=0.26 l=10m
R6 m1_8994_2542# a_7512_2477# sky130_fd_pr__res_generic_m1 w=2.5 l=10m
R7 m1_7727_3684# a_7462_4229# sky130_fd_pr__res_generic_m1 w=0.64 l=10m
X32 VCC_IO a_n461_4027# a_9935_2938# VCC_IO sky130_fd_pr__pfet_g5v0d10v5 ad=0.63 pd=3.42 as=0.42 ps=3.28 w=3 l=0.6
R8 a_8354_3203# m1_8330_3159# sky130_fd_pr__res_generic_m1 w=0.65 l=10m
R9 m1_10312_2627# m1_10351_2626# sky130_fd_pr__res_generic_m1 w=0.26 l=10m
R10 a_7462_4229# m1_10378_2741# sky130_fd_pr__res_generic_m1 w=0.26 l=10m
X33 a_4416_3253# a_1106_3203# a_1106_3203# VCC_IO sky130_fd_pr__pfet_g5v0d10v5 ad=1.325 pd=10.53 as=0.7 ps=5.28 w=5 l=0.5
X34 a_7512_2477# sky130_fd_io__gpiov2_octl_0/PDEN_H_N[1] VGND_IO VGND_IO sky130_fd_pr__nfet_g5v0d10v5 ad=0.14 pd=1.28 as=0.14 ps=1.28 w=1 l=0.6
X35 a_11053_559# a_10919_675# a_10398_443# VCC_IO sky130_fd_pr__pfet_g5v0d10v5 ad=0.0588 pd=0.7 as=0.1113 ps=1.37 w=0.42 l=0.5
X36 a_1106_3203# a_1106_3203# a_4416_3253# VCC_IO sky130_fd_pr__pfet_g5v0d10v5 ad=0.7 pd=5.28 as=0.7 ps=5.28 w=5 l=0.5
R11 m1_10523_1531# VCC_IO sky130_fd_pr__res_generic_m1 w=0.26 l=10m
X37 a_1106_3203# a_1106_3203# a_4416_3253# VCC_IO sky130_fd_pr__pfet_g5v0d10v5 ad=0.7 pd=5.28 as=0.7 ps=5.28 w=5 l=0.5
X38 a_9656_1708# DRVHI_H PU_H_N[1] VGND_IO sky130_fd_pr__nfet_g5v0d10v5 ad=0.42 pd=3.28 as=0.42 ps=3.28 w=3 l=0.6
X39 a_3125_3203# a_1415_3203# VCC_IO VCC_IO sky130_fd_pr__pfet_g5v0d10v5 ad=0.7 pd=5.28 as=0.7 ps=5.28 w=5 l=0.5
X40 a_4416_3253# a_1106_3203# a_1106_3203# VCC_IO sky130_fd_pr__pfet_g5v0d10v5 ad=0.7 pd=5.28 as=0.7 ps=5.28 w=5 l=0.5
X41 PD_H[2] DRVLO_H_N a_10194_3718# VCC_IO sky130_fd_pr__pfet_g5v0d10v5 ad=0.795 pd=6.53 as=0.42 ps=3.28 w=3 l=0.5
X42 a_12137_3347# DRVLO_H_N PD_H[4] VCC_IO sky130_fd_pr__pfet_g5v0d10v5 ad=0.0588 pd=0.7 as=0.1113 ps=1.37 w=0.42 l=1
R12 m1_9138_2849# a_1106_3203# sky130_fd_pr__res_generic_m1 w=0.26 l=10m
X43 a_1159_3105# DRVLO_H_N VCC_IO VCC_IO sky130_fd_pr__pfet_g5v0d10v5 ad=0.14 pd=1.28 as=0.265 ps=2.53 w=1 l=0.5
X44 VGND a_n408_4001# a_n461_4027# VGND sky130_fd_pr__nfet_g5v0d10v5 ad=0.098 pd=0.98 as=0.1855 ps=1.93 w=0.7 l=0.6
X45 PD_H[3] sky130_fd_io__gpiov2_obpredrvr_0/sky130_fd_io__gpiov2_pdpredrvr_strong_0/sky130_fd_io__gpiov2_octl_mux_0/Y_H VGND_IO VGND_IO sky130_fd_pr__nfet_g5v0d10v5 ad=0.42 pd=3.28 as=0.42 ps=3.28 w=3 l=0.6
X46 VCC_IO sky130_fd_io__gpiov2_octl_0/SLOW_H a_n408_4001# VCC_IO sky130_fd_pr__pfet_g5v0d10v5 ad=0.265 pd=2.53 as=0.14 ps=1.28 w=1 l=0.6
X47 VGND_IO a_7610_2597# a_9179_2770# VGND_IO sky130_fd_pr__nfet_g5v0d10v5 ad=0.265 pd=2.53 as=0.14 ps=1.28 w=1 l=1
X48 PD_H[3] sky130_fd_io__gpiov2_octl_0/PDEN_H_N[1] VGND_IO VGND_IO sky130_fd_pr__nfet_g5v0d10v5 ad=0.42 pd=3.28 as=0.42 ps=3.28 w=3 l=0.6
X49 VCC_IO a_1415_3203# a_3125_3203# VCC_IO sky130_fd_pr__pfet_g5v0d10v5 ad=0.7 pd=5.28 as=0.7 ps=5.28 w=5 l=0.5
X50 a_3125_3203# a_1415_3203# VCC_IO VCC_IO sky130_fd_pr__pfet_g5v0d10v5 ad=0.7 pd=5.28 as=1.325 ps=10.53 w=5 l=0.5
X51 a_7613_3603# a_7462_4229# VCC_IO VCC_IO sky130_fd_pr__pfet_g5v0d10v5 ad=0.315 pd=3.21 as=0.795 ps=6.53 w=3 l=0.5
R13 a_11085_1123# m1_10523_1531# sky130_fd_pr__res_generic_m1 w=0.26 l=10m
X52 sky130_fd_io__gpiov2_obpredrvr_0/sky130_fd_io__gpiov2_pdpredrvr_strong_0/sky130_fd_io__gpiov2_octl_mux_0/SEL_H sky130_fd_io__gpiov2_obpredrvr_0/sky130_fd_io__gpiov2_pdpredrvr_strong_0/sky130_fd_io__gpiov2_octl_mux_0/SEL_H_N VCC_IO VCC_IO sky130_fd_pr__pfet_g5v0d10v5 ad=0.265 pd=2.53 as=0.265 ps=2.53 w=1 l=0.6
X53 VCC_IO a_1159_3105# a_1106_3203# VCC_IO sky130_fd_pr__pfet_g5v0d10v5 ad=0.7 pd=5.28 as=1.325 ps=10.53 w=5 l=0.5
X54 a_10873_1155# sky130_fd_io__gpiov2_obpredrvr_0/sky130_fd_io__gpiov2_pdpredrvr_strong_0/sky130_fd_io__gpiov2_octl_mux_0/Y_H PD_H[3] VCC_IO sky130_fd_pr__pfet_g5v0d10v5 ad=0.21 pd=1.78 as=0.21 ps=1.78 w=1.5 l=0.5
X55 PD_H[2] DRVLO_H_N VGND_IO VGND_IO sky130_fd_pr__nfet_g5v0d10v5 ad=0.42 pd=3.28 as=0.42 ps=3.28 w=3 l=0.6
X56 VGND a_n408_1837# a_n461_1863# VGND sky130_fd_pr__nfet_g5v0d10v5 ad=0.098 pd=0.98 as=0.1855 ps=1.93 w=0.7 l=0.6
X57 VCC_IO a_n408_1837# a_n461_1863# VCC_IO sky130_fd_pr__pfet_g5v0d10v5 ad=0.14 pd=1.28 as=0.265 ps=2.53 w=1 l=0.6
X58 a_11862_3305# sky130_fd_io__gpiov2_octl_0/PDEN_H_N[1] a_11009_3305# VCC_IO sky130_fd_pr__pfet_g5v0d10v5 ad=0.1113 pd=1.37 as=0.1113 ps=1.37 w=0.42 l=4
X59 PD_H[3] sky130_fd_io__gpiov2_obpredrvr_0/sky130_fd_io__gpiov2_pdpredrvr_strong_0/sky130_fd_io__gpiov2_octl_mux_0/Y_H a_10564_1155# VCC_IO sky130_fd_pr__pfet_g5v0d10v5 ad=0.21 pd=1.78 as=0.3975 ps=3.53 w=1.5 l=0.5
X60 a_8876_944# DRVLO_H_N PD_H[1] VCC_IO sky130_fd_pr__pfet_g5v0d10v5 ad=0.795 pd=6.53 as=0.42 ps=3.28 w=3 l=0.5
X61 PD_H[4] sky130_fd_io__gpiov2_octl_0/PDEN_H_N[1] VGND_IO VGND_IO sky130_fd_pr__nfet_g5v0d10v5 ad=0.42 pd=3.28 as=0.42 ps=3.28 w=3 l=0.6
X62 a_7755_3603# a_7638_3476# a_7613_3603# VCC_IO sky130_fd_pr__pfet_g5v0d10v5 ad=0.315 pd=3.21 as=0.315 ps=3.21 w=3 l=0.5
X63 PD_H[2] DRVLO_H_N a_9882_3718# VCC_IO sky130_fd_pr__pfet_g5v0d10v5 ad=0.42 pd=3.28 as=0.42 ps=3.28 w=3 l=0.5
X64 VCC_IO PD_H[4] sky130_fd_io__gpiov2_obpredrvr_0/sky130_fd_io__gpiov2_pdpredrvr_strong_0/sky130_fd_io__gpiov2_octl_mux_0/A_H VCC_IO sky130_fd_pr__pfet_g5v0d10v5 ad=0.795 pd=6.53 as=0.795 ps=6.53 w=3 l=0.5
R14 m1_10547_2769# a_10919_675# sky130_fd_pr__res_generic_m1 w=0.26 l=10m
X65 sky130_fd_io__gpiov2_obpredrvr_0/sky130_fd_io__gpiov2_pdpredrvr_strong_0/sky130_fd_io__gpiov2_octl_mux_0/SEL_H sky130_fd_io__gpiov2_obpredrvr_0/sky130_fd_io__gpiov2_pdpredrvr_strong_0/sky130_fd_io__gpiov2_octl_mux_0/SEL_H_N VGND VGND sky130_fd_pr__nfet_g5v0d10v5 ad=0.1855 pd=1.93 as=0.1855 ps=1.93 w=0.7 l=0.6
X66 a_11009_3305# DRVLO_H_N PD_H[2] VCC_IO sky130_fd_pr__pfet_g5v0d10v5 ad=0.1113 pd=1.37 as=0.1113 ps=1.37 w=0.42 l=4
X67 a_9656_1708# sky130_fd_io__gpiov2_obpredrvr_0/sky130_fd_io__gpio_pupredrvr_strongv2_0/PUEN_H VGND_IO VGND_IO sky130_fd_pr__nfet_g5v0d10v5 ad=0.795 pd=6.53 as=0.42 ps=3.28 w=3 l=0.6
X68 a_n112_4027# sky130_fd_io__gpiov2_obpredrvr_0/sky130_fd_io__gpiov2_pdpredrvr_strong_0/sky130_fd_io__gpiov2_octl_mux_0/SEL_H_N VGND VGND sky130_fd_pr__nfet_g5v0d10v5 ad=0.098 pd=0.98 as=0.098 ps=0.98 w=0.7 l=0.6
X69 VGND_IO sky130_fd_io__gpiov2_obpredrvr_0/sky130_fd_io__gpiov2_pdpredrvr_strong_0/sky130_fd_io__gpiov2_octl_mux_0/Y_H PD_H[3] VGND_IO sky130_fd_pr__nfet_g5v0d10v5 ad=0.42 pd=3.28 as=0.42 ps=3.28 w=3 l=0.6
X70 VCC_IO sky130_fd_io__gpiov2_octl_0/SLOW_H a_n408_1837# VCC_IO sky130_fd_pr__pfet_g5v0d10v5 ad=0.265 pd=2.53 as=0.14 ps=1.28 w=1 l=0.6
X71 a_7610_2597# DRVLO_H_N a_7755_3603# VCC_IO sky130_fd_pr__pfet_g5v0d10v5 ad=0.795 pd=6.53 as=0.315 ps=3.21 w=3 l=0.5
X72 VGND_IO sky130_fd_io__gpiov2_obpredrvr_0/sky130_fd_io__gpiov2_pdpredrvr_strong_0/sky130_fd_io__gpiov2_octl_mux_0/Y_H PD_H[3] VGND_IO sky130_fd_pr__nfet_g5v0d10v5 ad=0.42 pd=3.28 as=0.42 ps=3.28 w=3 l=0.6
R15 m1_4181_3684# a_4416_3253# sky130_fd_pr__res_generic_m1 w=0.23 l=10m
X73 a_n112_1863# sky130_fd_io__gpiov2_obpredrvr_0/sky130_fd_io__gpiov2_pdpredrvr_strong_0/sky130_fd_io__gpiov2_octl_mux_0/SEL_H VGND VGND sky130_fd_pr__nfet_g5v0d10v5 ad=0.098 pd=0.98 as=0.098 ps=0.98 w=0.7 l=0.6
X74 a_9179_2770# a_7610_2597# VGND_IO VGND_IO sky130_fd_pr__nfet_g5v0d10v5 ad=0.14 pd=1.28 as=0.14 ps=1.28 w=1 l=1
X75 VGND_IO DRVLO_H_N PD_H[2] VGND_IO sky130_fd_pr__nfet_g5v0d10v5 ad=0.42 pd=3.28 as=0.42 ps=3.28 w=3 l=0.6
X76 VGND_IO a_n461_4027# a_7161_3177# VGND_IO sky130_fd_pr__nfet_g5v0d10v5 ad=0.21 pd=1.42 as=0.14 ps=1.28 w=1 l=0.6
X77 a_n408_1837# sky130_fd_io__gpiov2_obpredrvr_0/sky130_fd_io__gpiov2_pdpredrvr_strong_0/sky130_fd_io__gpiov2_octl_mux_0/SEL_H VCC_IO VCC_IO sky130_fd_pr__pfet_g5v0d10v5 ad=0.14 pd=1.28 as=0.14 ps=1.28 w=1 l=0.6
X78 VGND_IO sky130_fd_io__gpiov2_octl_0/PDEN_H_N[1] PD_H[2] VGND_IO sky130_fd_pr__nfet_g5v0d10v5 ad=0.42 pd=3.28 as=0.42 ps=3.28 w=3 l=0.6
X79 VCC_IO a_n408_4001# a_n461_4027# VCC_IO sky130_fd_pr__pfet_g5v0d10v5 ad=0.14 pd=1.28 as=0.265 ps=2.53 w=1 l=0.6
X80 a_4416_3253# a_4416_3253# VCC_IO VCC_IO sky130_fd_pr__pfet_g5v0d10v5 ad=0.7 pd=5.28 as=0.7 ps=5.28 w=5 l=0.5
X81 a_1106_3203# a_7610_2597# VGND_IO VGND_IO sky130_fd_pr__nfet_g5v0d10v5 ad=0.14 pd=1.28 as=0.14 ps=1.28 w=1 l=1
X82 a_8354_4056# PD_H[4] VGND_IO VGND_IO sky130_fd_pr__nfet_g5v0d10v5 ad=0.1113 pd=1.37 as=0.1113 ps=1.37 w=0.42 l=4
R16 m1_7764_3684# a_7638_3476# sky130_fd_pr__res_generic_m1 w=0.64 l=10m
X83 a_4416_3253# a_1106_3203# a_1106_3203# VCC_IO sky130_fd_pr__pfet_g5v0d10v5 ad=0.7 pd=5.28 as=0.7 ps=5.28 w=5 l=0.5
X84 a_1528_3203# a_2205_3177# a_2205_3177# VCC_IO sky130_fd_pr__pfet_g5v0d10v5 ad=0.7 pd=5.28 as=0.7 ps=5.28 w=5 l=0.5
X85 a_1106_3203# a_1106_3203# a_4416_3253# VCC_IO sky130_fd_pr__pfet_g5v0d10v5 ad=0.7 pd=5.28 as=1.325 ps=10.53 w=5 l=0.5
X86 a_10194_3718# DRVLO_H_N PD_H[2] VCC_IO sky130_fd_pr__pfet_g5v0d10v5 ad=0.42 pd=3.28 as=0.42 ps=3.28 w=3 l=0.5
R17 m1_5837_4210# a_1106_3203# sky130_fd_pr__res_generic_m1 w=0.23 l=10m
X87 PU_H_N[1] sky130_fd_io__gpiov2_obpredrvr_0/sky130_fd_io__gpio_pupredrvr_strongv2_0/PUEN_H VCC_IO VCC_IO sky130_fd_pr__pfet_g5v0d10v5 ad=0.795 pd=6.53 as=0.42 ps=3.28 w=3 l=0.5
X88 a_1415_3203# a_1528_3203# a_1528_3203# VCC_IO sky130_fd_pr__pfet_g5v0d10v5 ad=0.7 pd=5.28 as=1.325 ps=10.53 w=5 l=0.5
X89 a_7638_3476# a_7638_3476# a_7512_2477# VGND_IO sky130_fd_pr__nfet_g5v0d10v5 ad=0.795 pd=6.53 as=0.795 ps=6.53 w=3 l=0.5
X90 a_2205_3177# a_2205_3177# a_1528_3203# VCC_IO sky130_fd_pr__pfet_g5v0d10v5 ad=0.7 pd=5.28 as=0.7 ps=5.28 w=5 l=0.5
X91 VGND_IO sky130_fd_io__gpiov2_obpredrvr_0/sky130_fd_io__gpio_pupredrvr_strongv2_0/PUEN_H a_9656_1708# VGND_IO sky130_fd_pr__nfet_g5v0d10v5 ad=0.42 pd=3.28 as=0.42 ps=3.28 w=3 l=0.6
X92 a_1106_3203# a_7161_3177# VCC_IO VCC_IO sky130_fd_pr__pfet_g5v0d10v5 ad=1.325 pd=10.53 as=0.7 ps=5.28 w=5 l=0.5
X93 PU_H_N[0] DRVHI_H VCC_IO VCC_IO sky130_fd_pr__pfet_g5v0d10v5 ad=0.7 pd=5.28 as=1.325 ps=10.53 w=5 l=0.6
X94 VGND_IO sky130_fd_io__gpiov2_obpredrvr_0/sky130_fd_io__gpiov2_pdpredrvr_strong_0/sky130_fd_io__gpiov2_octl_mux_0/Y_H PD_H[3] VGND_IO sky130_fd_pr__nfet_g5v0d10v5 ad=0.42 pd=3.28 as=0.795 ps=6.53 w=3 l=0.6
X95 VCC_IO a_4416_3253# a_4416_3253# VCC_IO sky130_fd_pr__pfet_g5v0d10v5 ad=0.7 pd=5.28 as=0.7 ps=5.28 w=5 l=0.5
X96 VCC_IO a_4416_3253# a_4416_3253# VCC_IO sky130_fd_pr__pfet_g5v0d10v5 ad=0.7 pd=5.28 as=0.7 ps=5.28 w=5 l=0.5
R18 m1_9138_2849# a_9179_2770# sky130_fd_pr__res_generic_m1 w=0.26 l=10m
X97 a_4416_3253# a_4416_3253# VCC_IO VCC_IO sky130_fd_pr__pfet_g5v0d10v5 ad=0.7 pd=5.28 as=0.7 ps=5.28 w=5 l=0.5
X98 a_9290_3718# a_n461_1863# VCC_IO VCC_IO sky130_fd_pr__pfet_g5v0d10v5 ad=0.42 pd=3.28 as=0.795 ps=6.53 w=3 l=0.5
X99 VCC_IO sky130_fd_io__gpiov2_octl_0/PDEN_H_N[1] a_11009_3747# VCC_IO sky130_fd_pr__pfet_g5v0d10v5 ad=0.1113 pd=1.37 as=0.1113 ps=1.37 w=0.42 l=4
X100 PU_H_N[1] DRVHI_H VCC_IO VCC_IO sky130_fd_pr__pfet_g5v0d10v5 ad=0.42 pd=3.28 as=0.42 ps=3.28 w=3 l=0.5
X101 VCC_IO a_n408_1837# a_n461_1863# VCC_IO sky130_fd_pr__pfet_g5v0d10v5 ad=0.14 pd=1.28 as=0.265 ps=2.53 w=1 l=0.6
X102 VCC_IO sky130_fd_io__gpiov2_octl_0/SLOW_H a_n408_4001# VCC_IO sky130_fd_pr__pfet_g5v0d10v5 ad=0.265 pd=2.53 as=0.14 ps=1.28 w=1 l=0.6
X103 a_n408_4001# sky130_fd_io__gpiov2_obpredrvr_0/sky130_fd_io__gpiov2_pdpredrvr_strong_0/sky130_fd_io__gpiov2_octl_mux_0/SEL_H_N VCC_IO VCC_IO sky130_fd_pr__pfet_g5v0d10v5 ad=0.14 pd=1.28 as=0.14 ps=1.28 w=1 l=0.6
X104 VGND_IO DRVLO_H_N a_7512_2477# VGND_IO sky130_fd_pr__nfet_g5v0d10v5 ad=0.14 pd=1.28 as=0.14 ps=1.28 w=1 l=0.6
X105 VCC_IO a_1106_3203# a_12137_3347# VCC_IO sky130_fd_pr__pfet_g5v0d10v5 ad=0.1113 pd=1.37 as=0.1113 ps=1.37 w=0.42 l=1
R19 m1_10375_2471# a_1106_3203# sky130_fd_pr__res_generic_m1 w=0.26 l=10m
R20 m1_4181_3684# a_3125_3203# sky130_fd_pr__res_generic_m1 w=0.23 l=10m
X106 PD_H[3] sky130_fd_io__gpiov2_obpredrvr_0/sky130_fd_io__gpiov2_pdpredrvr_strong_0/sky130_fd_io__gpiov2_octl_mux_0/Y_H a_10849_843# VCC_IO sky130_fd_pr__pfet_g5v0d10v5 ad=0.0588 pd=0.7 as=0.1113 ps=1.37 w=0.42 l=2
X107 VCC_IO VGND_IO a_1415_3203# VCC_IO sky130_fd_pr__pfet_g5v0d10v5 ad=0.1113 pd=1.37 as=0.1113 ps=1.37 w=0.42 l=8
R21 m1_8014_3310# a_8026_3203# sky130_fd_pr__res_generic_m1 w=0.65 l=10m
X108 VGND_IO sky130_fd_io__gpiov2_octl_0/PDEN_H_N[1] PD_H[3] VGND_IO sky130_fd_pr__nfet_g5v0d10v5 ad=0.795 pd=6.53 as=0.42 ps=3.28 w=3 l=0.6
X109 a_7610_2597# a_7512_2477# VGND_IO VGND_IO sky130_fd_pr__nfet_g5v0d10v5 ad=1.325 pd=10.53 as=1.325 ps=10.53 w=5 l=0.6
X110 a_10398_443# a_n461_1863# VCC_IO VCC_IO sky130_fd_pr__pfet_g5v0d10v5 ad=0.265 pd=2.53 as=0.14 ps=1.28 w=1 l=0.5
X111 a_4416_3253# a_1106_3203# a_1106_3203# VCC_IO sky130_fd_pr__pfet_g5v0d10v5 ad=0.7 pd=5.28 as=0.7 ps=5.28 w=5 l=0.5
R22 m1_10375_2471# a_10919_675# sky130_fd_pr__res_generic_m1 w=0.26 l=10m
R23 m1_9297_3844# PD_H[4] sky130_fd_pr__res_generic_m1 w=0.26 l=10m
X112 a_10398_443# a_11085_1123# a_11053_559# VCC_IO sky130_fd_pr__pfet_g5v0d10v5 ad=0.1113 pd=1.37 as=0.0588 ps=0.7 w=0.42 l=0.5
X113 a_n408_1837# sky130_fd_io__gpiov2_obpredrvr_0/sky130_fd_io__gpiov2_pdpredrvr_strong_0/sky130_fd_io__gpiov2_octl_mux_0/SEL_H VCC_IO VCC_IO sky130_fd_pr__pfet_g5v0d10v5 ad=0.14 pd=1.28 as=0.14 ps=1.28 w=1 l=0.6
X114 VGND_IO DRVLO_H_N a_1159_3105# VGND_IO sky130_fd_pr__nfet_g5v0d10v5 ad=0.14 pd=1.28 as=0.265 ps=2.53 w=1 l=0.6
X115 VGND_IO DRVLO_H_N PD_H[4] VGND_IO sky130_fd_pr__nfet_g5v0d10v5 ad=0.42 pd=3.28 as=0.42 ps=3.28 w=3 l=0.6
X116 PD_H[2] a_n461_1863# VGND_IO VGND_IO sky130_fd_pr__nfet_g5v0d10v5 ad=0.42 pd=3.28 as=0.795 ps=6.53 w=3 l=0.6
X117 VCC_IO DRVHI_H PU_H_N[0] VCC_IO sky130_fd_pr__pfet_g5v0d10v5 ad=0.7 pd=5.28 as=0.7 ps=5.28 w=5 l=0.6
X118 PD_H[1] sky130_fd_io__gpiov2_octl_0/PDEN_H_N[1] VGND_IO VGND_IO sky130_fd_pr__nfet_g5v0d10v5 ad=0.42 pd=3.28 as=0.795 ps=6.53 w=3 l=0.6
X119 VGND_IO DRVLO_H_N a_7610_2597# VGND_IO sky130_fd_pr__nfet_g5v0d10v5 ad=0.14 pd=1.28 as=0.14 ps=1.28 w=1 l=0.6
X120 a_11862_3305# sky130_fd_io__gpiov2_octl_0/PDEN_H_N[1] a_9290_3718# VCC_IO sky130_fd_pr__pfet_g5v0d10v5 ad=0.1113 pd=1.37 as=0.1113 ps=1.37 w=0.42 l=4
X121 VCC_IO a_1415_3203# a_3125_3203# VCC_IO sky130_fd_pr__pfet_g5v0d10v5 ad=0.7 pd=5.28 as=0.7 ps=5.28 w=5 l=0.5
X122 a_4416_3253# a_4416_3253# VCC_IO VCC_IO sky130_fd_pr__pfet_g5v0d10v5 ad=0.7 pd=5.28 as=1.325 ps=10.53 w=5 l=0.5
R24 a_1106_3203# m1_8014_3310# sky130_fd_pr__res_generic_m1 w=0.65 l=10m
X123 VCC_IO a_1415_3203# a_3125_3203# VCC_IO sky130_fd_pr__pfet_g5v0d10v5 ad=1.325 pd=10.53 as=0.7 ps=5.28 w=5 l=0.5
X124 a_9290_3718# a_n461_1863# VCC_IO VCC_IO sky130_fd_pr__pfet_g5v0d10v5 ad=0.795 pd=6.53 as=0.42 ps=3.28 w=3 l=0.5
X125 a_3125_3203# a_1415_3203# VCC_IO VCC_IO sky130_fd_pr__pfet_g5v0d10v5 ad=0.7 pd=5.28 as=0.7 ps=5.28 w=5 l=0.5
X126 a_9935_2938# sky130_fd_io__gpiov2_octl_0/PDEN_H_N[1] a_7161_3177# VCC_IO sky130_fd_pr__pfet_g5v0d10v5 ad=0.42 pd=3.28 as=1.005 ps=6.67 w=3 l=0.6
X127 VCC_IO a_n408_4001# a_n461_4027# VCC_IO sky130_fd_pr__pfet_g5v0d10v5 ad=0.14 pd=1.28 as=0.265 ps=2.53 w=1 l=0.6
X128 a_1528_3203# a_1528_3203# a_1415_3203# VCC_IO sky130_fd_pr__pfet_g5v0d10v5 ad=0.7 pd=5.28 as=0.7 ps=5.28 w=5 l=0.5
R25 m1_9297_3844# a_7638_3476# sky130_fd_pr__res_generic_m1 w=0.26 l=10m
X129 a_11053_559# sky130_fd_io__gpiov2_obpredrvr_0/sky130_fd_io__gpiov2_pdpredrvr_strong_0/sky130_fd_io__gpiov2_octl_mux_0/Y_H PD_H[3] VCC_IO sky130_fd_pr__pfet_g5v0d10v5 ad=0.1113 pd=1.37 as=0.0588 ps=0.7 w=0.42 l=0.5
X130 VCC_IO a_10919_675# a_10873_1155# VCC_IO sky130_fd_pr__pfet_g5v0d10v5 ad=0.21 pd=1.78 as=0.21 ps=1.78 w=1.5 l=0.5
X131 a_7462_4229# a_7161_3177# VCC_IO VCC_IO sky130_fd_pr__pfet_g5v0d10v5 ad=0.795 pd=6.53 as=0.63 ps=3.42 w=3 l=0.6
R26 m1_5874_4210# a_4416_3253# sky130_fd_pr__res_generic_m1 w=0.23 l=10m
X132 a_10398_443# sky130_fd_io__gpiov2_octl_0/PDEN_H_N[1] a_11758_843# VCC_IO sky130_fd_pr__pfet_g5v0d10v5 ad=0.1113 pd=1.37 as=0.0588 ps=0.7 w=0.42 l=2
X133 VCC_IO a_4416_3253# a_4416_3253# VCC_IO sky130_fd_pr__pfet_g5v0d10v5 ad=0.7 pd=5.28 as=0.7 ps=5.28 w=5 l=0.5
X134 a_10194_3718# a_1106_3203# a_9290_3718# VCC_IO sky130_fd_pr__pfet_g5v0d10v5 ad=0.795 pd=6.53 as=0.42 ps=3.28 w=3 l=0.5
X135 PU_H_N[1] DRVHI_H a_9656_1708# VGND_IO sky130_fd_pr__nfet_g5v0d10v5 ad=0.42 pd=3.28 as=0.795 ps=6.53 w=3 l=0.6
X136 PD_H[1] DRVLO_H_N a_8876_944# VCC_IO sky130_fd_pr__pfet_g5v0d10v5 ad=0.42 pd=3.28 as=0.42 ps=3.28 w=3 l=0.5
X137 a_7610_2597# a_7462_4229# VGND_IO VGND_IO sky130_fd_pr__nfet_g5v0d10v5 ad=0.14 pd=1.28 as=0.14 ps=1.28 w=1 l=0.6
X138 VGND_IO DRVLO_H_N PD_H[1] VGND_IO sky130_fd_pr__nfet_g5v0d10v5 ad=0.795 pd=6.53 as=0.42 ps=3.28 w=3 l=0.6
X139 a_7743_1707# DRVHI_H PU_H_N[0] VGND_IO sky130_fd_pr__nfet_g5v0d10v5 ad=0.42 pd=3.28 as=0.795 ps=6.53 w=3 l=0.6
X140 PD_H[4] DRVLO_H_N VGND_IO VGND_IO sky130_fd_pr__nfet_g5v0d10v5 ad=0.795 pd=6.53 as=0.42 ps=3.28 w=3 l=0.6
X141 a_2205_3177# a_7610_2597# VGND_IO VGND_IO sky130_fd_pr__nfet_g5v0d10v5 ad=1.325 pd=10.53 as=1.325 ps=10.53 w=5 l=0.6
R27 m1_10778_2548# a_11085_1123# sky130_fd_pr__res_generic_m1 w=0.26 l=10m
X142 a_9882_3718# DRVLO_H_N PD_H[2] VCC_IO sky130_fd_pr__pfet_g5v0d10v5 ad=0.42 pd=3.28 as=0.795 ps=6.53 w=3 l=0.5
X143 VCC_IO sky130_fd_io__gpiov2_octl_0/PDEN_H_N[1] a_10849_843# VCC_IO sky130_fd_pr__pfet_g5v0d10v5 ad=0.1113 pd=1.37 as=0.1113 ps=1.37 w=0.42 l=4
X144 PD_H[4] DRVLO_H_N a_11009_3747# VCC_IO sky130_fd_pr__pfet_g5v0d10v5 ad=0.1113 pd=1.37 as=0.1113 ps=1.37 w=0.42 l=4
X145 a_n408_4001# sky130_fd_io__gpiov2_obpredrvr_0/sky130_fd_io__gpiov2_pdpredrvr_strong_0/sky130_fd_io__gpiov2_octl_mux_0/SEL_H_N VCC_IO VCC_IO sky130_fd_pr__pfet_g5v0d10v5 ad=0.14 pd=1.28 as=0.14 ps=1.28 w=1 l=0.6
X146 PD_H[4] DRVLO_H_N a_12137_3347# VCC_IO sky130_fd_pr__pfet_g5v0d10v5 ad=0.1113 pd=1.37 as=0.0588 ps=0.7 w=0.42 l=1
X147 VCC_IO a_n461_1863# a_10398_443# VCC_IO sky130_fd_pr__pfet_g5v0d10v5 ad=0.14 pd=1.28 as=0.265 ps=2.53 w=1 l=0.5
X148 VCC_IO sky130_fd_io__gpiov2_octl_0/PDEN_H_N[1] a_8876_944# VCC_IO sky130_fd_pr__pfet_g5v0d10v5 ad=0.42 pd=3.28 as=0.795 ps=6.53 w=3 l=0.5
.ends

.subckt sky130_fd_io__com_res_weak_bentbigres a_419_6804# a_419_8054# a_n256_8772#
+ a_419_8146# a_419_9396# a_n2_6046#
X0 a_419_8054# a_419_6804# sky130_fd_pr__res_generic_po w=0.8 l=6
X1 a_n256_8772# a_n258_6046# sky130_fd_pr__res_generic_po w=0.8 l=12
X2 a_419_9396# a_419_8146# sky130_fd_pr__res_generic_po w=0.8 l=6
X3 a_n258_6046# a_n2_6046# sky130_fd_pr__res_generic_po w=0.8 l=50
.ends

.subckt sky130_fd_io__com_res_weak RA RB
Xsky130_fd_io__com_res_weak_bentbigres_0 li_n135_6820# li_n135_8054# li_n135_6820#
+ li_n135_8054# a_n160_9488# RA sky130_fd_io__com_res_weak_bentbigres
R0 m1_n147_9555# a_n160_9488# sky130_fd_pr__res_generic_m1 w=0.66 l=10m
R1 m1_n146_7434# li_n135_6820# sky130_fd_pr__res_generic_m1 w=0.66 l=10m
X0 a_n160_10423# a_n160_9838# sky130_fd_pr__res_generic_po w=0.8 l=1.5
X1 a_n160_9838# a_n160_9488# sky130_fd_pr__res_generic_po w=0.8 l=1.5
R2 a_n160_10423# m1_n147_10115# sky130_fd_pr__res_generic_m1 w=0.66 l=10m
R3 a_n160_9488# m1_n147_8777# sky130_fd_pr__res_generic_m1 w=0.66 l=10m
R4 a_n160_10423# m1_532_10115# sky130_fd_pr__res_generic_m1 w=0.66 l=10m
R5 a_517_9818# m1_532_9534# sky130_fd_pr__res_generic_m1 w=0.66 l=10m
R6 m1_n147_8777# li_n135_8054# sky130_fd_pr__res_generic_m1 w=0.66 l=10m
R7 m1_n147_10115# a_n160_9838# sky130_fd_pr__res_generic_m1 w=0.66 l=10m
R8 m1_532_10115# a_517_9818# sky130_fd_pr__res_generic_m1 w=0.66 l=10m
X2 a_517_9818# RB sky130_fd_pr__res_generic_po w=0.8 l=1.5
R9 m1_532_9534# RB sky130_fd_pr__res_generic_m1 w=0.66 l=10m
R10 a_n160_9838# m1_n147_9555# sky130_fd_pr__res_generic_m1 w=0.66 l=10m
R11 li_n135_8054# m1_n146_7735# sky130_fd_pr__res_generic_m1 w=0.66 l=10m
X3 a_n160_10423# a_517_9818# sky130_fd_pr__res_generic_po w=0.8 l=1.5
.ends

.subckt sky130_fd_io__pfet_con_diff_wo_abt_270v2 w_415_600# a_2303_1380# a_13777_1380#
+ a_8817_1380# a_4287_1380# a_7263_1380# a_12223_1380# a_9247_1380# a_2865_1380# a_5841_1380#
+ a_4849_1380# a_10801_1380# a_14135_1380# a_1311_1380# a_12785_1380# a_7825_1380#
+ a_3295_1380# a_9809_1380# a_1001_1552# a_6271_1380# a_5279_1380# a_11231_1380# a_10239_1380#
+ a_8255_1380# a_1873_1380# a_13215_1380# a_3857_1380# a_11793_1380# a_881_1380# a_6833_1380#
X0 a_1001_1552# a_13777_1380# w_415_600# w_415_600# sky130_fd_pr__pfet_g5v0d10v5 ad=2.975 pd=6.19 as=3.775 ps=11.51 w=5 l=0.6
X1 w_415_600# a_10239_1380# a_1001_1552# w_415_600# sky130_fd_pr__pfet_g5v0d10v5 ad=3.775 pd=11.51 as=3.875 ps=6.55 w=5 l=0.6
X2 a_1001_1552# a_1873_1380# w_415_600# w_415_600# sky130_fd_pr__pfet_g5v0d10v5 ad=3.875 pd=6.55 as=3.775 ps=11.51 w=5 l=0.6
X3 a_1001_1552# a_8817_1380# w_415_600# w_415_600# sky130_fd_pr__pfet_g5v0d10v5 ad=3.875 pd=6.55 as=3.775 ps=11.51 w=5 l=0.6
X4 w_415_600# a_14135_1380# a_1001_1552# w_415_600# sky130_fd_pr__pfet_g5v0d10v5 ad=4.3 pd=11.72 as=2.975 ps=6.19 w=5 l=0.6
X5 w_415_600# a_3295_1380# a_1001_1552# w_415_600# sky130_fd_pr__pfet_g5v0d10v5 ad=3.775 pd=11.51 as=3.875 ps=6.55 w=5 l=0.6
X6 a_1001_1552# a_5841_1380# w_415_600# w_415_600# sky130_fd_pr__pfet_g5v0d10v5 ad=3.875 pd=6.55 as=3.775 ps=11.51 w=5 l=0.6
X7 w_415_600# a_2303_1380# a_1001_1552# w_415_600# sky130_fd_pr__pfet_g5v0d10v5 ad=3.775 pd=11.51 as=3.875 ps=6.55 w=5 l=0.6
X8 w_415_600# a_7263_1380# a_1001_1552# w_415_600# sky130_fd_pr__pfet_g5v0d10v5 ad=3.775 pd=11.51 as=3.875 ps=6.55 w=5 l=0.6
X9 a_1001_1552# a_4849_1380# w_415_600# w_415_600# sky130_fd_pr__pfet_g5v0d10v5 ad=3.875 pd=6.55 as=3.775 ps=11.51 w=5 l=0.6
X10 w_415_600# a_11231_1380# a_1001_1552# w_415_600# sky130_fd_pr__pfet_g5v0d10v5 ad=3.775 pd=11.51 as=3.875 ps=6.55 w=5 l=0.6
X11 a_1001_1552# a_12785_1380# w_415_600# w_415_600# sky130_fd_pr__pfet_g5v0d10v5 ad=3.875 pd=6.55 as=3.775 ps=11.51 w=5 l=0.6
X12 w_415_600# a_10239_1380# a_1001_1552# w_415_600# sky130_fd_pr__pfet_g5v0d10v5 ad=3.775 pd=11.51 as=3.875 ps=6.55 w=5 l=0.6
X13 a_1001_1552# a_8817_1380# w_415_600# w_415_600# sky130_fd_pr__pfet_g5v0d10v5 ad=3.875 pd=6.55 as=3.775 ps=11.51 w=5 l=0.6
X14 w_415_600# a_3295_1380# a_1001_1552# w_415_600# sky130_fd_pr__pfet_g5v0d10v5 ad=3.775 pd=11.51 as=3.875 ps=6.55 w=5 l=0.6
X15 w_415_600# a_2303_1380# a_1001_1552# w_415_600# sky130_fd_pr__pfet_g5v0d10v5 ad=3.775 pd=11.51 as=3.875 ps=6.55 w=5 l=0.6
X16 w_415_600# a_7263_1380# a_1001_1552# w_415_600# sky130_fd_pr__pfet_g5v0d10v5 ad=3.775 pd=11.51 as=3.875 ps=6.55 w=5 l=0.6
X17 a_1001_1552# a_12785_1380# w_415_600# w_415_600# sky130_fd_pr__pfet_g5v0d10v5 ad=3.875 pd=6.55 as=3.775 ps=11.51 w=5 l=0.6
X18 a_1001_1552# a_3857_1380# w_415_600# w_415_600# sky130_fd_pr__pfet_g5v0d10v5 ad=3.875 pd=6.55 as=3.775 ps=11.51 w=5 l=0.6
X19 a_1001_1552# a_7825_1380# w_415_600# w_415_600# sky130_fd_pr__pfet_g5v0d10v5 ad=3.875 pd=6.55 as=3.775 ps=11.51 w=5 l=0.6
X20 w_415_600# a_13215_1380# a_1001_1552# w_415_600# sky130_fd_pr__pfet_g5v0d10v5 ad=3.775 pd=11.51 as=3.875 ps=6.55 w=5 l=0.6
X21 w_415_600# a_1311_1380# a_1001_1552# w_415_600# sky130_fd_pr__pfet_g5v0d10v5 ad=3.775 pd=11.51 as=3.875 ps=6.55 w=5 l=0.6
X22 w_415_600# a_6271_1380# a_1001_1552# w_415_600# sky130_fd_pr__pfet_g5v0d10v5 ad=3.775 pd=11.51 as=3.875 ps=6.55 w=5 l=0.6
X23 a_1001_1552# a_3857_1380# w_415_600# w_415_600# sky130_fd_pr__pfet_g5v0d10v5 ad=3.875 pd=6.55 as=3.775 ps=11.51 w=5 l=0.6
X24 w_415_600# a_5279_1380# a_1001_1552# w_415_600# sky130_fd_pr__pfet_g5v0d10v5 ad=3.775 pd=11.51 as=3.875 ps=6.55 w=5 l=0.6
X25 a_1001_1552# a_11793_1380# w_415_600# w_415_600# sky130_fd_pr__pfet_g5v0d10v5 ad=3.875 pd=6.55 as=3.775 ps=11.51 w=5 l=0.6
X26 a_1001_1552# a_7825_1380# w_415_600# w_415_600# sky130_fd_pr__pfet_g5v0d10v5 ad=3.875 pd=6.55 as=3.775 ps=11.51 w=5 l=0.6
X27 a_1001_1552# a_10801_1380# w_415_600# w_415_600# sky130_fd_pr__pfet_g5v0d10v5 ad=3.875 pd=6.55 as=3.775 ps=11.51 w=5 l=0.6
X28 w_415_600# a_13215_1380# a_1001_1552# w_415_600# sky130_fd_pr__pfet_g5v0d10v5 ad=3.775 pd=11.51 as=3.875 ps=6.55 w=5 l=0.6
X29 w_415_600# a_9247_1380# a_1001_1552# w_415_600# sky130_fd_pr__pfet_g5v0d10v5 ad=3.775 pd=11.51 as=3.875 ps=6.55 w=5 l=0.6
X30 w_415_600# a_1311_1380# a_1001_1552# w_415_600# sky130_fd_pr__pfet_g5v0d10v5 ad=3.775 pd=11.51 as=3.875 ps=6.55 w=5 l=0.6
X31 w_415_600# a_6271_1380# a_1001_1552# w_415_600# sky130_fd_pr__pfet_g5v0d10v5 ad=3.775 pd=11.51 as=3.875 ps=6.55 w=5 l=0.6
X32 a_1001_1552# a_881_1380# w_415_600# w_415_600# sky130_fd_pr__pfet_g5v0d10v5 ad=3.875 pd=6.55 as=4.325 ps=11.73 w=5 l=0.6
X33 w_415_600# a_5279_1380# a_1001_1552# w_415_600# sky130_fd_pr__pfet_g5v0d10v5 ad=3.775 pd=11.51 as=3.875 ps=6.55 w=5 l=0.6
X34 a_1001_1552# a_11793_1380# w_415_600# w_415_600# sky130_fd_pr__pfet_g5v0d10v5 ad=3.875 pd=6.55 as=3.775 ps=11.51 w=5 l=0.6
X35 a_1001_1552# a_2865_1380# w_415_600# w_415_600# sky130_fd_pr__pfet_g5v0d10v5 ad=3.875 pd=6.55 as=3.775 ps=11.51 w=5 l=0.6
X36 a_1001_1552# a_6833_1380# w_415_600# w_415_600# sky130_fd_pr__pfet_g5v0d10v5 ad=3.875 pd=6.55 as=3.775 ps=11.51 w=5 l=0.6
X37 w_415_600# a_9247_1380# a_1001_1552# w_415_600# sky130_fd_pr__pfet_g5v0d10v5 ad=3.775 pd=11.51 as=3.875 ps=6.55 w=5 l=0.6
X38 a_1001_1552# a_10801_1380# w_415_600# w_415_600# sky130_fd_pr__pfet_g5v0d10v5 ad=3.875 pd=6.55 as=3.775 ps=11.51 w=5 l=0.6
X39 w_415_600# a_12223_1380# a_1001_1552# w_415_600# sky130_fd_pr__pfet_g5v0d10v5 ad=3.775 pd=11.51 as=3.875 ps=6.55 w=5 l=0.6
X40 a_1001_1552# a_881_1380# w_415_600# w_415_600# sky130_fd_pr__pfet_g5v0d10v5 ad=3.875 pd=6.55 as=4.325 ps=11.73 w=5 l=0.6
X41 a_1001_1552# a_9809_1380# w_415_600# w_415_600# sky130_fd_pr__pfet_g5v0d10v5 ad=3.875 pd=6.55 as=3.775 ps=11.51 w=5 l=0.6
X42 a_1001_1552# a_2865_1380# w_415_600# w_415_600# sky130_fd_pr__pfet_g5v0d10v5 ad=3.875 pd=6.55 as=3.775 ps=11.51 w=5 l=0.6
X43 w_415_600# a_4287_1380# a_1001_1552# w_415_600# sky130_fd_pr__pfet_g5v0d10v5 ad=3.775 pd=11.51 as=3.875 ps=6.55 w=5 l=0.6
X44 a_1001_1552# a_6833_1380# w_415_600# w_415_600# sky130_fd_pr__pfet_g5v0d10v5 ad=3.875 pd=6.55 as=3.775 ps=11.51 w=5 l=0.6
X45 w_415_600# a_8255_1380# a_1001_1552# w_415_600# sky130_fd_pr__pfet_g5v0d10v5 ad=3.775 pd=11.51 as=3.875 ps=6.55 w=5 l=0.6
X46 w_415_600# a_12223_1380# a_1001_1552# w_415_600# sky130_fd_pr__pfet_g5v0d10v5 ad=3.775 pd=11.51 as=3.875 ps=6.55 w=5 l=0.6
X47 a_1001_1552# a_13777_1380# w_415_600# w_415_600# sky130_fd_pr__pfet_g5v0d10v5 ad=2.975 pd=6.19 as=3.775 ps=11.51 w=5 l=0.6
X48 a_1001_1552# a_9809_1380# w_415_600# w_415_600# sky130_fd_pr__pfet_g5v0d10v5 ad=3.875 pd=6.55 as=3.775 ps=11.51 w=5 l=0.6
X49 a_1001_1552# a_1873_1380# w_415_600# w_415_600# sky130_fd_pr__pfet_g5v0d10v5 ad=3.875 pd=6.55 as=3.775 ps=11.51 w=5 l=0.6
X50 w_415_600# a_4287_1380# a_1001_1552# w_415_600# sky130_fd_pr__pfet_g5v0d10v5 ad=3.775 pd=11.51 as=3.875 ps=6.55 w=5 l=0.6
X51 w_415_600# a_14135_1380# a_1001_1552# w_415_600# sky130_fd_pr__pfet_g5v0d10v5 ad=4.3 pd=11.72 as=2.975 ps=6.19 w=5 l=0.6
X52 a_1001_1552# a_5841_1380# w_415_600# w_415_600# sky130_fd_pr__pfet_g5v0d10v5 ad=3.875 pd=6.55 as=3.775 ps=11.51 w=5 l=0.6
X53 w_415_600# a_11231_1380# a_1001_1552# w_415_600# sky130_fd_pr__pfet_g5v0d10v5 ad=3.775 pd=11.51 as=3.875 ps=6.55 w=5 l=0.6
X54 w_415_600# a_8255_1380# a_1001_1552# w_415_600# sky130_fd_pr__pfet_g5v0d10v5 ad=3.775 pd=11.51 as=3.875 ps=6.55 w=5 l=0.6
X55 a_1001_1552# a_4849_1380# w_415_600# w_415_600# sky130_fd_pr__pfet_g5v0d10v5 ad=3.875 pd=6.55 as=3.775 ps=11.51 w=5 l=0.6
.ends

.subckt sky130_fd_io__gpio_pudrvr_strongv2 PU_H_N[3] PU_H_N[2] VCC_IO m1_1330_n459#
+ TIE_HI_ESD m1_6027_281# m1_3418_50# VNB a_14575_n157# m1_6652_281# m1_3028_333#
+ PAD m1_14880_n614# li_9083_n155#
Xsky130_fd_io__pfet_con_diff_wo_abt_270v2_0 VCC_IO PU_H_N[2] m1_14229_1478# m1_8837_1478#
+ PU_H_N[3] PU_H_N[3] m1_11745_1478# m1_8837_1478# PU_H_N[2] PU_H_N[3] PU_H_N[3] m1_10391_1478#
+ m1_14229_1478# PU_H_N[2] PU_H_N[2] PU_H_N[3] PU_H_N[2] m1_10391_1478# PAD PU_H_N[3]
+ PU_H_N[3] m1_11745_1478# m1_10391_1478# m1_8837_1478# PU_H_N[2] m1_13667_1478# PU_H_N[3]
+ m1_11745_1478# PU_H_N[2] PU_H_N[3] sky130_fd_io__pfet_con_diff_wo_abt_270v2
R0 m2_14075_657# PU_H_N[2] sky130_fd_pr__res_generic_m2 w=0.65 l=10m
R1 m1_14229_1478# m2_14532_958# sky130_fd_pr__res_generic_m2 w=0.65 l=10m
R2 m1_13667_1478# m2_13593_958# sky130_fd_pr__res_generic_m2 w=0.65 l=10m
R3 m2_12849_n185# PU_H_N[2] sky130_fd_pr__res_generic_m2 w=0.65 l=10m
R4 m1_8837_1478# m2_10673_n208# sky130_fd_pr__res_generic_m2 w=0.65 l=10m
R5 m1_10391_1478# m2_10945_92# sky130_fd_pr__res_generic_m2 w=0.65 l=10m
R6 m2_10673_n208# PU_H_N[2] sky130_fd_pr__res_generic_m2 w=0.65 l=10m
R7 m2_11422_n209# PU_H_N[2] sky130_fd_pr__res_generic_m2 w=0.65 l=10m
R8 m1_13667_1478# m2_14075_958# sky130_fd_pr__res_generic_m2 w=0.65 l=10m
R9 m2_10197_n209# TIE_HI_ESD sky130_fd_pr__res_generic_m2 w=0.65 l=10m
R10 m2_10945_n209# TIE_HI_ESD sky130_fd_pr__res_generic_m2 w=0.65 l=10m
R11 m1_11745_1478# m2_12608_116# sky130_fd_pr__res_generic_m2 w=0.65 l=10m
R12 m1_10391_1478# m2_11422_92# sky130_fd_pr__res_generic_m2 w=0.65 l=10m
R13 m1_11745_1478# m2_12849_116# sky130_fd_pr__res_generic_m2 w=0.65 l=10m
R14 m2_12608_n185# PU_H_N[3] sky130_fd_pr__res_generic_m2 w=0.65 l=10m
R15 m2_13837_658# PU_H_N[3] sky130_fd_pr__res_generic_m2 w=0.65 l=10m
R16 m2_14769_657# PU_H_N[2] sky130_fd_pr__res_generic_m2 w=0.65 l=10m
R17 m2_11186_n208# PU_H_N[3] sky130_fd_pr__res_generic_m2 w=0.65 l=10m
R18 m2_14286_658# TIE_HI_ESD sky130_fd_pr__res_generic_m2 w=0.65 l=10m
X0 TIE_HI_ESD a_14575_n157# sky130_fd_pr__res_generic_po w=0.5 l=10.2
R19 m1_8837_1478# m2_10197_92# sky130_fd_pr__res_generic_m2 w=0.65 l=10m
R20 m1_8837_1478# m2_10439_92# sky130_fd_pr__res_generic_m2 w=0.65 l=10m
R21 m2_14532_657# PU_H_N[3] sky130_fd_pr__res_generic_m2 w=0.65 l=10m
R22 m1_10391_1478# m2_11186_n208# sky130_fd_pr__res_generic_m2 w=0.65 l=10m
R23 m2_13593_657# TIE_HI_ESD sky130_fd_pr__res_generic_m2 w=0.65 l=10m
R24 m1_13667_1478# m2_13837_658# sky130_fd_pr__res_generic_m2 w=0.65 l=10m
R25 m1_14229_1478# m2_14769_958# sky130_fd_pr__res_generic_m2 w=0.65 l=10m
R26 m1_11745_1478# m2_12365_n184# sky130_fd_pr__res_generic_m2 w=0.65 l=10m
R27 m2_10439_n209# PU_H_N[3] sky130_fd_pr__res_generic_m2 w=0.65 l=10m
R28 m2_12365_n184# TIE_HI_ESD sky130_fd_pr__res_generic_m2 w=0.65 l=10m
R29 m1_14229_1478# m2_14286_658# sky130_fd_pr__res_generic_m2 w=0.65 l=10m
.ends

.subckt sky130_fd_io__nfet_con_diff_wo_abt_270v2 VCC_IO VSSIO PAD a_10282_1285# a_5322_1285#
+ a_12266_1285# a_7306_1285# a_3900_1285# a_2908_1285# a_5884_1285# a_14178_1285#
+ a_10844_1285# a_1354_1285# a_7868_1285# a_12828_1285# a_8860_1285# a_13820_1285#
+ a_4330_1285# a_3338_1285# a_11274_1285# a_6314_1285# a_8298_1285# a_13258_1285#
+ a_9290_1285# a_1916_1285# a_4892_1285# a_6876_1285# a_924_1285# a_11836_1285# a_2346_1285#
+ a_9852_1285#
X0 PAD a_10844_1285# VSSIO VSSIO sky130_fd_pr__nfet_g5v0d10v5 ad=3.875 pd=6.55 as=3.775 ps=11.51 w=5 l=0.6
X1 PAD a_9852_1285# VSSIO VSSIO sky130_fd_pr__nfet_g5v0d10v5 ad=3.875 pd=6.55 as=3.775 ps=11.51 w=5 l=0.6
X2 VSSIO a_2346_1285# PAD VSSIO sky130_fd_pr__nfet_g5v0d10v5 ad=3.775 pd=11.51 as=3.875 ps=6.55 w=5 l=0.6
X3 PAD a_1916_1285# VSSIO VSSIO sky130_fd_pr__nfet_g5v0d10v5 ad=3.875 pd=6.55 as=3.775 ps=11.51 w=5 l=0.6
X4 PAD a_6876_1285# VSSIO VSSIO sky130_fd_pr__nfet_g5v0d10v5 ad=3.875 pd=6.55 as=3.775 ps=11.51 w=5 l=0.6
X5 VSSIO a_12266_1285# PAD VSSIO sky130_fd_pr__nfet_g5v0d10v5 ad=3.775 pd=11.51 as=3.875 ps=6.55 w=5 l=0.6
X6 VSSIO a_6314_1285# PAD VSSIO sky130_fd_pr__nfet_g5v0d10v5 ad=3.775 pd=11.51 as=3.875 ps=6.55 w=5 l=0.6
X7 PAD a_11836_1285# VSSIO VSSIO sky130_fd_pr__nfet_g5v0d10v5 ad=3.875 pd=6.55 as=3.775 ps=11.51 w=5 l=0.6
X8 VSSIO a_9290_1285# PAD VSSIO sky130_fd_pr__nfet_g5v0d10v5 ad=3.775 pd=11.51 as=3.875 ps=6.55 w=5 l=0.6
X9 PAD a_4892_1285# VSSIO VSSIO sky130_fd_pr__nfet_g5v0d10v5 ad=3.875 pd=6.55 as=3.775 ps=11.51 w=5 l=0.6
X10 VSSIO a_4330_1285# PAD VSSIO sky130_fd_pr__nfet_g5v0d10v5 ad=3.775 pd=11.51 as=3.875 ps=6.55 w=5 l=0.6
X11 PAD a_8860_1285# VSSIO VSSIO sky130_fd_pr__nfet_g5v0d10v5 ad=3.875 pd=6.55 as=3.775 ps=11.51 w=5 l=0.6
X12 VSSIO a_10282_1285# PAD VSSIO sky130_fd_pr__nfet_g5v0d10v5 ad=3.775 pd=11.51 as=3.875 ps=6.55 w=5 l=0.6
X13 VSSIO a_3338_1285# PAD VSSIO sky130_fd_pr__nfet_g5v0d10v5 ad=3.775 pd=11.51 as=3.875 ps=6.55 w=5 l=0.6
X14 VSSIO a_8298_1285# PAD VSSIO sky130_fd_pr__nfet_g5v0d10v5 ad=3.775 pd=11.51 as=3.875 ps=6.55 w=5 l=0.6
X15 PAD a_924_1285# VSSIO VSSIO sky130_fd_pr__nfet_g5v0d10v5 ad=3.875 pd=6.55 as=3.425 ps=11.37 w=5 l=0.6
X16 PAD a_3900_1285# VSSIO VSSIO sky130_fd_pr__nfet_g5v0d10v5 ad=3.875 pd=6.55 as=3.775 ps=11.51 w=5 l=0.6
X17 PAD a_13820_1285# VSSIO VSSIO sky130_fd_pr__nfet_g5v0d10v5 ad=2.975 pd=6.19 as=3.775 ps=11.51 w=5 l=0.6
X18 PAD a_2908_1285# VSSIO VSSIO sky130_fd_pr__nfet_g5v0d10v5 ad=3.875 pd=6.55 as=3.775 ps=11.51 w=5 l=0.6
X19 PAD a_7868_1285# VSSIO VSSIO sky130_fd_pr__nfet_g5v0d10v5 ad=3.875 pd=6.55 as=3.775 ps=11.51 w=5 l=0.6
X20 VSSIO a_13258_1285# PAD VSSIO sky130_fd_pr__nfet_g5v0d10v5 ad=3.775 pd=11.51 as=3.875 ps=6.55 w=5 l=0.6
X21 VSSIO a_7306_1285# PAD VSSIO sky130_fd_pr__nfet_g5v0d10v5 ad=3.775 pd=11.51 as=3.875 ps=6.55 w=5 l=0.6
X22 PAD a_12828_1285# VSSIO VSSIO sky130_fd_pr__nfet_g5v0d10v5 ad=3.875 pd=6.55 as=3.775 ps=11.51 w=5 l=0.6
X23 VSSIO a_14178_1285# PAD VSSIO sky130_fd_pr__nfet_g5v0d10v5 ad=3.425 pd=11.37 as=2.975 ps=6.19 w=5 l=0.6
X24 VSSIO a_1354_1285# PAD VSSIO sky130_fd_pr__nfet_g5v0d10v5 ad=3.775 pd=11.51 as=3.875 ps=6.55 w=5 l=0.6
X25 PAD a_5884_1285# VSSIO VSSIO sky130_fd_pr__nfet_g5v0d10v5 ad=3.875 pd=6.55 as=3.775 ps=11.51 w=5 l=0.6
X26 VSSIO a_11274_1285# PAD VSSIO sky130_fd_pr__nfet_g5v0d10v5 ad=3.775 pd=11.51 as=3.875 ps=6.55 w=5 l=0.6
X27 VSSIO a_5322_1285# PAD VSSIO sky130_fd_pr__nfet_g5v0d10v5 ad=3.775 pd=11.51 as=3.875 ps=6.55 w=5 l=0.6
X28 PAD a_9852_1285# VSSIO VSSIO sky130_fd_pr__nfet_g5v0d10v5 ad=3.875 pd=6.55 as=3.775 ps=11.51 w=5 l=0.6
X29 PAD a_10844_1285# VSSIO VSSIO sky130_fd_pr__nfet_g5v0d10v5 ad=3.875 pd=6.55 as=3.775 ps=11.51 w=5 l=0.6
X30 VSSIO a_2346_1285# PAD VSSIO sky130_fd_pr__nfet_g5v0d10v5 ad=3.775 pd=11.51 as=3.875 ps=6.55 w=5 l=0.6
X31 PAD a_6876_1285# VSSIO VSSIO sky130_fd_pr__nfet_g5v0d10v5 ad=3.875 pd=6.55 as=3.775 ps=11.51 w=5 l=0.6
X32 VSSIO a_6314_1285# PAD VSSIO sky130_fd_pr__nfet_g5v0d10v5 ad=3.775 pd=11.51 as=3.875 ps=6.55 w=5 l=0.6
X33 PAD a_1916_1285# VSSIO VSSIO sky130_fd_pr__nfet_g5v0d10v5 ad=3.875 pd=6.55 as=3.775 ps=11.51 w=5 l=0.6
X34 VSSIO a_12266_1285# PAD VSSIO sky130_fd_pr__nfet_g5v0d10v5 ad=3.775 pd=11.51 as=3.875 ps=6.55 w=5 l=0.6
X35 PAD a_11836_1285# VSSIO VSSIO sky130_fd_pr__nfet_g5v0d10v5 ad=3.875 pd=6.55 as=3.775 ps=11.51 w=5 l=0.6
X36 PAD a_4892_1285# VSSIO VSSIO sky130_fd_pr__nfet_g5v0d10v5 ad=3.875 pd=6.55 as=3.775 ps=11.51 w=5 l=0.6
X37 VSSIO a_9290_1285# PAD VSSIO sky130_fd_pr__nfet_g5v0d10v5 ad=3.775 pd=11.51 as=3.875 ps=6.55 w=5 l=0.6
X38 PAD a_8860_1285# VSSIO VSSIO sky130_fd_pr__nfet_g5v0d10v5 ad=3.875 pd=6.55 as=3.775 ps=11.51 w=5 l=0.6
X39 VSSIO a_10282_1285# PAD VSSIO sky130_fd_pr__nfet_g5v0d10v5 ad=3.775 pd=11.51 as=3.875 ps=6.55 w=5 l=0.6
X40 VSSIO a_4330_1285# PAD VSSIO sky130_fd_pr__nfet_g5v0d10v5 ad=3.775 pd=11.51 as=3.875 ps=6.55 w=5 l=0.6
X41 PAD a_924_1285# VSSIO VSSIO sky130_fd_pr__nfet_g5v0d10v5 ad=3.875 pd=6.55 as=3.425 ps=11.37 w=5 l=0.6
X42 PAD a_3900_1285# VSSIO VSSIO sky130_fd_pr__nfet_g5v0d10v5 ad=3.875 pd=6.55 as=3.775 ps=11.51 w=5 l=0.6
X43 VSSIO a_3338_1285# PAD VSSIO sky130_fd_pr__nfet_g5v0d10v5 ad=3.775 pd=11.51 as=3.875 ps=6.55 w=5 l=0.6
X44 VSSIO a_8298_1285# PAD VSSIO sky130_fd_pr__nfet_g5v0d10v5 ad=3.775 pd=11.51 as=3.875 ps=6.55 w=5 l=0.6
X45 PAD a_2908_1285# VSSIO VSSIO sky130_fd_pr__nfet_g5v0d10v5 ad=3.875 pd=6.55 as=3.775 ps=11.51 w=5 l=0.6
X46 PAD a_7868_1285# VSSIO VSSIO sky130_fd_pr__nfet_g5v0d10v5 ad=3.875 pd=6.55 as=3.775 ps=11.51 w=5 l=0.6
X47 VSSIO a_7306_1285# PAD VSSIO sky130_fd_pr__nfet_g5v0d10v5 ad=3.775 pd=11.51 as=3.875 ps=6.55 w=5 l=0.6
X48 PAD a_13820_1285# VSSIO VSSIO sky130_fd_pr__nfet_g5v0d10v5 ad=2.975 pd=6.19 as=3.775 ps=11.51 w=5 l=0.6
X49 VSSIO a_13258_1285# PAD VSSIO sky130_fd_pr__nfet_g5v0d10v5 ad=3.775 pd=11.51 as=3.875 ps=6.55 w=5 l=0.6
X50 PAD a_12828_1285# VSSIO VSSIO sky130_fd_pr__nfet_g5v0d10v5 ad=3.875 pd=6.55 as=3.775 ps=11.51 w=5 l=0.6
X51 VSSIO a_1354_1285# PAD VSSIO sky130_fd_pr__nfet_g5v0d10v5 ad=3.775 pd=11.51 as=3.875 ps=6.55 w=5 l=0.6
X52 VSSIO a_14178_1285# PAD VSSIO sky130_fd_pr__nfet_g5v0d10v5 ad=3.425 pd=11.37 as=2.975 ps=6.19 w=5 l=0.6
X53 PAD a_5884_1285# VSSIO VSSIO sky130_fd_pr__nfet_g5v0d10v5 ad=3.875 pd=6.55 as=3.775 ps=11.51 w=5 l=0.6
X54 VSSIO a_5322_1285# PAD VSSIO sky130_fd_pr__nfet_g5v0d10v5 ad=3.775 pd=11.51 as=3.875 ps=6.55 w=5 l=0.6
X55 VSSIO a_11274_1285# PAD VSSIO sky130_fd_pr__nfet_g5v0d10v5 ad=3.775 pd=11.51 as=3.875 ps=6.55 w=5 l=0.6
.ends

.subckt sky130_fd_io__gpiov2_pddrvr_strong sky130_fd_io__nfet_con_diff_wo_abt_270v2_0/a_3338_1285#
+ sky130_fd_io__nfet_con_diff_wo_abt_270v2_0/a_4330_1285# sky130_fd_io__nfet_con_diff_wo_abt_270v2_0/a_10282_1285#
+ sky130_fd_io__nfet_con_diff_wo_abt_270v2_0/a_6314_1285# sky130_fd_io__nfet_con_diff_wo_abt_270v2_0/a_12266_1285#
+ sky130_fd_io__nfet_con_diff_wo_abt_270v2_0/a_8298_1285# sky130_fd_io__nfet_con_diff_wo_abt_270v2_0/a_9290_1285#
+ sky130_fd_io__nfet_con_diff_wo_abt_270v2_0/a_1916_1285# sky130_fd_io__nfet_con_diff_wo_abt_270v2_0/VSSIO
+ sky130_fd_io__nfet_con_diff_wo_abt_270v2_0/a_4892_1285# sky130_fd_io__nfet_con_diff_wo_abt_270v2_0/VCC_IO
+ sky130_fd_io__nfet_con_diff_wo_abt_270v2_0/a_10844_1285# sky130_fd_io__nfet_con_diff_wo_abt_270v2_0/PAD
+ sky130_fd_io__nfet_con_diff_wo_abt_270v2_0/a_6876_1285# sky130_fd_io__nfet_con_diff_wo_abt_270v2_0/a_14178_1285#
+ sky130_fd_io__nfet_con_diff_wo_abt_270v2_0/a_2346_1285# sky130_fd_io__nfet_con_diff_wo_abt_270v2_0/a_12828_1285#
+ sky130_fd_io__nfet_con_diff_wo_abt_270v2_0/a_13820_1285# sky130_fd_io__nfet_con_diff_wo_abt_270v2_0/a_924_1285#
+ sky130_fd_io__nfet_con_diff_wo_abt_270v2_0/a_9852_1285# sky130_fd_io__nfet_con_diff_wo_abt_270v2_0/a_5322_1285#
+ sky130_fd_io__nfet_con_diff_wo_abt_270v2_0/a_11274_1285# sky130_fd_io__nfet_con_diff_wo_abt_270v2_0/a_7306_1285#
+ sky130_fd_io__nfet_con_diff_wo_abt_270v2_0/a_13258_1285# sky130_fd_io__nfet_con_diff_wo_abt_270v2_0/a_3900_1285#
+ sky130_fd_io__nfet_con_diff_wo_abt_270v2_0/a_2908_1285# sky130_fd_io__nfet_con_diff_wo_abt_270v2_0/a_5884_1285#
+ sky130_fd_io__nfet_con_diff_wo_abt_270v2_0/a_1354_1285# sky130_fd_io__nfet_con_diff_wo_abt_270v2_0/a_7868_1285#
+ sky130_fd_io__nfet_con_diff_wo_abt_270v2_0/a_11836_1285# sky130_fd_io__nfet_con_diff_wo_abt_270v2_0/a_8860_1285#
Xsky130_fd_io__nfet_con_diff_wo_abt_270v2_0 sky130_fd_io__nfet_con_diff_wo_abt_270v2_0/VCC_IO
+ sky130_fd_io__nfet_con_diff_wo_abt_270v2_0/VSSIO sky130_fd_io__nfet_con_diff_wo_abt_270v2_0/PAD
+ sky130_fd_io__nfet_con_diff_wo_abt_270v2_0/a_10282_1285# sky130_fd_io__nfet_con_diff_wo_abt_270v2_0/a_5322_1285#
+ sky130_fd_io__nfet_con_diff_wo_abt_270v2_0/a_12266_1285# sky130_fd_io__nfet_con_diff_wo_abt_270v2_0/a_7306_1285#
+ sky130_fd_io__nfet_con_diff_wo_abt_270v2_0/a_3900_1285# sky130_fd_io__nfet_con_diff_wo_abt_270v2_0/a_2908_1285#
+ sky130_fd_io__nfet_con_diff_wo_abt_270v2_0/a_5884_1285# sky130_fd_io__nfet_con_diff_wo_abt_270v2_0/a_14178_1285#
+ sky130_fd_io__nfet_con_diff_wo_abt_270v2_0/a_10844_1285# sky130_fd_io__nfet_con_diff_wo_abt_270v2_0/a_1354_1285#
+ sky130_fd_io__nfet_con_diff_wo_abt_270v2_0/a_7868_1285# sky130_fd_io__nfet_con_diff_wo_abt_270v2_0/a_12828_1285#
+ sky130_fd_io__nfet_con_diff_wo_abt_270v2_0/a_8860_1285# sky130_fd_io__nfet_con_diff_wo_abt_270v2_0/a_13820_1285#
+ sky130_fd_io__nfet_con_diff_wo_abt_270v2_0/a_4330_1285# sky130_fd_io__nfet_con_diff_wo_abt_270v2_0/a_3338_1285#
+ sky130_fd_io__nfet_con_diff_wo_abt_270v2_0/a_11274_1285# sky130_fd_io__nfet_con_diff_wo_abt_270v2_0/a_6314_1285#
+ sky130_fd_io__nfet_con_diff_wo_abt_270v2_0/a_8298_1285# sky130_fd_io__nfet_con_diff_wo_abt_270v2_0/a_13258_1285#
+ sky130_fd_io__nfet_con_diff_wo_abt_270v2_0/a_9290_1285# sky130_fd_io__nfet_con_diff_wo_abt_270v2_0/a_1916_1285#
+ sky130_fd_io__nfet_con_diff_wo_abt_270v2_0/a_4892_1285# sky130_fd_io__nfet_con_diff_wo_abt_270v2_0/a_6876_1285#
+ sky130_fd_io__nfet_con_diff_wo_abt_270v2_0/a_924_1285# sky130_fd_io__nfet_con_diff_wo_abt_270v2_0/a_11836_1285#
+ sky130_fd_io__nfet_con_diff_wo_abt_270v2_0/a_2346_1285# sky130_fd_io__nfet_con_diff_wo_abt_270v2_0/a_9852_1285#
+ sky130_fd_io__nfet_con_diff_wo_abt_270v2
.ends

.subckt sky130_fd_io__com_pudrvr_weakv2 PU_H_N PAD w_258_n30# a_756_297#
X0 PAD PU_H_N w_258_n30# w_258_n30# sky130_fd_pr__pfet_g5v0d10v5 ad=0.7 pd=5.28 as=0.7 ps=5.28 w=5 l=0.5
X1 PAD PU_H_N w_258_n30# w_258_n30# sky130_fd_pr__pfet_g5v0d10v5 ad=0.98 pd=7.28 as=0.98 ps=7.28 w=7 l=0.5
X2 w_258_n30# PU_H_N a_756_297# w_258_n30# sky130_fd_pr__pfet_g5v0d10v5 ad=0.7 pd=5.28 as=0.7 ps=5.28 w=5 l=0.5
X3 w_258_n30# PU_H_N a_756_297# w_258_n30# sky130_fd_pr__pfet_g5v0d10v5 ad=0.98 pd=7.28 as=0.98 ps=7.28 w=7 l=0.5
X4 w_258_n30# PU_H_N PAD w_258_n30# sky130_fd_pr__pfet_g5v0d10v5 ad=1.325 pd=10.53 as=0.7 ps=5.28 w=5 l=0.5
X5 w_258_n30# PU_H_N PAD w_258_n30# sky130_fd_pr__pfet_g5v0d10v5 ad=1.855 pd=14.53 as=0.98 ps=7.28 w=7 l=0.5
X6 a_756_297# PU_H_N w_258_n30# w_258_n30# sky130_fd_pr__pfet_g5v0d10v5 ad=0.7 pd=5.28 as=1.325 ps=10.53 w=5 l=0.5
X7 a_756_297# PU_H_N w_258_n30# w_258_n30# sky130_fd_pr__pfet_g5v0d10v5 ad=0.98 pd=7.28 as=1.855 ps=14.53 w=7 l=0.5
.ends

.subckt sky130_fd_io__res250_sub_small a_10_2# a_2142_2#
X0 a_10_2# a_2142_2# sky130_fd_pr__res_generic_po w=2 l=10.07
.ends

.subckt sky130_fd_io__res250only_small PAD ROUT
Xsky130_fd_io__res250_sub_small_0 PAD ROUT sky130_fd_io__res250_sub_small
.ends

.subckt sky130_fd_io__gpio_pddrvr_weakv2 PD_H PAD dw_n122_84# w_168_168#
X0 w_168_168# PD_H PAD w_168_168# sky130_fd_pr__nfet_g5v0d10v5 ad=1.325 pd=10.53 as=1.325 ps=10.53 w=5 l=0.6
X1 w_168_168# PD_H PAD w_168_168# sky130_fd_pr__nfet_g5v0d10v5 ad=1.325 pd=10.53 as=1.325 ps=10.53 w=5 l=0.6
X2 w_168_168# PD_H PAD w_168_168# sky130_fd_pr__nfet_g5v0d10v5 ad=1.325 pd=10.53 as=1.325 ps=10.53 w=5 l=0.6
X3 w_168_168# PD_H PAD w_168_168# sky130_fd_pr__nfet_g5v0d10v5 ad=1.325 pd=10.53 as=1.325 ps=10.53 w=5 l=0.6
X4 w_168_168# PD_H PAD w_168_168# sky130_fd_pr__nfet_g5v0d10v5 ad=1.325 pd=10.53 as=1.325 ps=10.53 w=5 l=0.6
X5 w_168_168# PD_H PAD w_168_168# sky130_fd_pr__nfet_g5v0d10v5 ad=1.325 pd=10.53 as=1.325 ps=10.53 w=5 l=0.6
.ends

.subckt sky130_fd_io__gpio_odrvr_subv2 VGND FORCE_HI_H_N FORCE_LO_H FORCE_LOVOL_H
+ PU_H_N[0] PU_H_N[1] PU_H_N[2] PU_H_N[3] VSSIO_AMX VGND_IO PD_H[0] PD_H[1] PD_H[2]
+ PD_H[3] TIE_LO_ESD w_588_14893# m3_6107_13425# w_n915_9930# li_5884_n9263# m2_8191_n10933#
+ sky130_fd_io__gpiov2_pddrvr_strong_0/sky130_fd_io__nfet_con_diff_wo_abt_270v2_0/VSSIO
+ sky130_fd_io__gpio_pudrvr_strongv2_0/m1_14880_n614# sky130_fd_io__gpio_pudrvr_strongv2_0/li_9083_n155#
+ TIE_HI_ESD m1_2782_13727# PAD w_5497_14893# VCC_IO
Xsky130_fd_io__com_res_weak_0 sky130_fd_io__com_res_weak_0/RA sky130_fd_io__com_res_weak_0/RB
+ sky130_fd_io__com_res_weak
Xsky130_fd_io__gpio_pudrvr_strongv2_0 PU_H_N[3] PU_H_N[2] VCC_IO VCC_IO TIE_HI_ESD
+ VCC_IO PU_H_N[0] VGND VCC_IO VCC_IO VCC_IO PAD sky130_fd_io__gpio_pudrvr_strongv2_0/m1_14880_n614#
+ sky130_fd_io__gpio_pudrvr_strongv2_0/li_9083_n155# sky130_fd_io__gpio_pudrvr_strongv2
Xsky130_fd_io__gpiov2_pddrvr_strong_0 m1_11278_13727# m1_9854_13727# PD_H[3] m1_8317_13727#
+ m1_2782_13727# PD_H[2] PD_H[3] m1_12832_13727# sky130_fd_io__gpiov2_pddrvr_strong_0/sky130_fd_io__nfet_con_diff_wo_abt_270v2_0/VSSIO
+ m1_9854_13727# VCC_IO PD_H[3] PAD m1_8317_13727# m1_870_13727# m1_12832_13727# m1_2220_13727#
+ m1_870_13727# m1_12832_13727# PD_H[3] m1_9854_13727# PD_H[3] m1_7742_13727# m1_870_13727#
+ m1_11278_13727# m1_11278_13727# m1_8317_13727# m1_12832_13727# PD_H[2] PD_H[3] PD_H[2]
+ sky130_fd_io__gpiov2_pddrvr_strong
Xsky130_fd_io__com_pudrvr_weakv2_0 PU_H_N[0] sky130_fd_io__com_res_weak_0/RA VCC_IO
+ sky130_fd_io__com_res_weak_0/RA sky130_fd_io__com_pudrvr_weakv2
Xsky130_fd_io__res250only_small_0 PAD sky130_fd_io__com_res_weak_0/RB sky130_fd_io__res250only_small
Xsky130_fd_io__gpio_pddrvr_weakv2_0 PD_H[0] sky130_fd_io__com_res_weak_0/RA VCC_IO
+ w_5497_14893# sky130_fd_io__gpio_pddrvr_weakv2
X0 TIE_LO_ESD VGND_IO sky130_fd_pr__res_generic_po w=0.5 l=10.2
R0 PD_H[2] m2_11414_16117# sky130_fd_pr__res_generic_m2 w=0.65 l=10m
X1 VCC_IO PU_H_N[1] a_782_15260# VCC_IO sky130_fd_pr__pfet_g5v0d10v5 ad=1.855 pd=14.53 as=0.98 ps=7.28 w=7 l=0.5
R1 TIE_LO_ESD m2_1933_16117# sky130_fd_pr__res_generic_m2 w=0.65 l=10m
R2 m2_12848_15816# m1_12832_13727# sky130_fd_pr__res_generic_m2 w=0.65 l=10m
X2 a_10314_7886# sky130_fd_io__com_res_weak_0/RB sky130_fd_pr__res_generic_po w=2 l=2
R3 m2_982_15816# m1_870_13727# sky130_fd_pr__res_generic_m2 w=0.65 l=10m
R4 PD_H[2] m2_10071_16117# sky130_fd_pr__res_generic_m2 w=0.65 l=10m
X3 a_782_15260# PD_H[1] w_588_14893# w_588_14893# sky130_fd_pr__nfet_g5v0d10v5 ad=1.325 pd=10.53 as=1.325 ps=10.53 w=5 l=0.6
X4 a_782_15260# PU_H_N[1] VCC_IO VCC_IO sky130_fd_pr__pfet_g5v0d10v5 ad=0.98 pd=7.28 as=1.855 ps=14.53 w=7 l=0.5
R5 TIE_LO_ESD m2_9451_16117# sky130_fd_pr__res_generic_m2 w=0.65 l=10m
X5 a_9612_7886# a_10314_7886# sky130_fd_pr__res_generic_po w=2 l=3
R6 PD_H[3] m2_7318_15817# sky130_fd_pr__res_generic_m2 w=0.65 l=10m
R7 m2_13278_15816# m1_12832_13727# sky130_fd_pr__res_generic_m2 w=0.65 l=10m
X6 a_782_15260# PD_H[1] w_588_14893# w_588_14893# sky130_fd_pr__nfet_g5v0d10v5 ad=1.325 pd=10.53 as=1.325 ps=10.53 w=5 l=0.6
R8 TIE_LO_ESD m2_499_16117# sky130_fd_pr__res_generic_m2 w=0.65 l=10m
R9 PD_H[2] m2_6889_16117# sky130_fd_pr__res_generic_m2 w=0.65 l=10m
R10 m2_11414_15816# m1_11278_13727# sky130_fd_pr__res_generic_m2 w=0.65 l=10m
X7 a_782_15260# PD_H[1] w_588_14893# w_588_14893# sky130_fd_pr__nfet_g5v0d10v5 ad=1.325 pd=10.53 as=1.325 ps=10.53 w=5 l=0.6
R11 m2_1933_15816# m1_2220_13727# sky130_fd_pr__res_generic_m2 w=0.65 l=10m
R12 TIE_LO_ESD m2_10931_16117# sky130_fd_pr__res_generic_m2 w=0.65 l=10m
R13 m2_10071_15816# m1_9854_13727# sky130_fd_pr__res_generic_m2 w=0.65 l=10m
R14 m2_9451_15816# m1_8317_13727# sky130_fd_pr__res_generic_m2 w=0.65 l=10m
R15 PD_H[3] m2_1650_16117# sky130_fd_pr__res_generic_m2 w=0.65 l=10m
R16 m2_7318_15817# m1_7742_13727# sky130_fd_pr__res_generic_m2 w=0.65 l=10m
X8 a_782_15260# PU_H_N[1] VCC_IO VCC_IO sky130_fd_pr__pfet_g5v0d10v5 ad=0.98 pd=7.28 as=1.855 ps=14.53 w=7 l=0.5
R17 PD_H[2] m2_1345_15817# sky130_fd_pr__res_generic_m2 w=0.65 l=10m
R18 m2_499_15816# m1_870_13727# sky130_fd_pr__res_generic_m2 w=0.65 l=10m
R19 m2_6889_15816# m1_7742_13727# sky130_fd_pr__res_generic_m2 w=0.65 l=10m
R20 m2_10931_15816# m1_9854_13727# sky130_fd_pr__res_generic_m2 w=0.65 l=10m
R21 TIE_LO_ESD m2_13707_15817# sky130_fd_pr__res_generic_m2 w=0.65 l=10m
R22 m1_9882_7996# a_10314_7886# sky130_fd_pr__res_generic_m1 w=1.32 l=10m
R23 PD_H[3] m2_9020_15817# sky130_fd_pr__res_generic_m2 w=0.65 l=10m
R24 PD_H[3] m2_740_15817# sky130_fd_pr__res_generic_m2 w=0.65 l=10m
R25 m2_1650_15816# m1_2220_13727# sky130_fd_pr__res_generic_m2 w=0.65 l=10m
R26 PD_H[2] m2_8591_16117# sky130_fd_pr__res_generic_m2 w=0.65 l=10m
X9 a_782_15260# PU_H_N[1] VCC_IO VCC_IO sky130_fd_pr__pfet_g5v0d10v5 ad=0.98 pd=7.28 as=0.98 ps=7.28 w=7 l=0.5
R27 m1_9882_7996# a_9612_7886# sky130_fd_pr__res_generic_m1 w=1.32 l=10m
R28 m2_1345_15817# m1_2220_13727# sky130_fd_pr__res_generic_m2 w=0.65 l=10m
X10 VCC_IO PU_H_N[1] a_782_15260# VCC_IO sky130_fd_pr__pfet_g5v0d10v5 ad=0.98 pd=7.28 as=0.98 ps=7.28 w=7 l=0.5
R29 PD_H[3] m2_10500_15817# sky130_fd_pr__res_generic_m2 w=0.65 l=10m
R30 m2_9020_15817# m1_8317_13727# sky130_fd_pr__res_generic_m2 w=0.65 l=10m
R31 PD_H[3] m2_11843_15817# sky130_fd_pr__res_generic_m2 w=0.65 l=10m
R32 m2_13707_15817# m1_12832_13727# sky130_fd_pr__res_generic_m2 w=0.65 l=10m
R33 m2_740_15817# m1_870_13727# sky130_fd_pr__res_generic_m2 w=0.65 l=10m
R34 m2_8591_15816# m1_8317_13727# sky130_fd_pr__res_generic_m2 w=0.65 l=10m
R35 TIE_LO_ESD m2_12274_16117# sky130_fd_pr__res_generic_m2 w=0.65 l=10m
R36 TIE_LO_ESD m2_7749_16117# sky130_fd_pr__res_generic_m2 w=0.65 l=10m
X11 a_782_15260# PD_H[1] w_588_14893# w_588_14893# sky130_fd_pr__nfet_g5v0d10v5 ad=1.325 pd=10.53 as=1.325 ps=10.53 w=5 l=0.6
X12 VCC_IO PU_H_N[1] a_782_15260# VCC_IO sky130_fd_pr__pfet_g5v0d10v5 ad=1.855 pd=14.53 as=0.98 ps=7.28 w=7 l=0.5
X13 a_782_15260# PU_H_N[1] VCC_IO VCC_IO sky130_fd_pr__pfet_g5v0d10v5 ad=0.98 pd=7.28 as=0.98 ps=7.28 w=7 l=0.5
R37 m2_10500_15817# m1_9854_13727# sky130_fd_pr__res_generic_m2 w=0.65 l=10m
R38 m2_11843_15817# m1_11278_13727# sky130_fd_pr__res_generic_m2 w=0.65 l=10m
X14 VCC_IO PU_H_N[1] a_782_15260# VCC_IO sky130_fd_pr__pfet_g5v0d10v5 ad=0.98 pd=7.28 as=0.98 ps=7.28 w=7 l=0.5
R39 PD_H[2] m2_982_16117# sky130_fd_pr__res_generic_m2 w=0.65 l=10m
R40 PD_H[2] m2_12848_16117# sky130_fd_pr__res_generic_m2 w=0.65 l=10m
R41 m2_12274_15816# m1_11278_13727# sky130_fd_pr__res_generic_m2 w=0.65 l=10m
R42 m2_7749_15816# m1_7742_13727# sky130_fd_pr__res_generic_m2 w=0.65 l=10m
R43 PD_H[3] m2_13278_16117# sky130_fd_pr__res_generic_m2 w=0.65 l=10m
X15 a_782_15260# a_9612_7886# sky130_fd_pr__res_generic_po w=2 l=5
.ends

.subckt sky130_fd_io__gpio_odrvrv2 PAD PU_H_N[0] PU_H_N[1] PU_H_N[2] PU_H_N[3] FORCE_HI_H_N
+ FORCE_LO_H VSSIO_AMX PD_H[0] PD_H[1] PD_H[2] PD_H[3] w_n915_9930# FORCE_LOVOL_H
+ sky130_fd_io__gpio_odrvr_subv2_0/m3_6107_13425# TIE_LO_ESD TIE_HI_ESD w_5497_14893#
+ sky130_fd_io__gpio_odrvr_subv2_0/li_5884_n9263# sky130_fd_io__gpio_odrvr_subv2_0/m2_8191_n10933#
+ w_588_14893# sky130_fd_io__gpio_odrvr_subv2_0/sky130_fd_io__gpio_pudrvr_strongv2_0/li_9083_n155#
+ sky130_fd_io__gpio_odrvr_subv2_0/sky130_fd_io__gpio_pudrvr_strongv2_0/m1_14880_n614#
+ sky130_fd_io__gpio_odrvr_subv2_0/m1_2782_13727# VGND VCC_IO VGND_IO
Xsky130_fd_io__gpio_odrvr_subv2_0 VGND FORCE_HI_H_N FORCE_LO_H FORCE_LOVOL_H PU_H_N[0]
+ PU_H_N[1] PU_H_N[2] PU_H_N[3] VSSIO_AMX VGND_IO PD_H[0] PD_H[1] PD_H[2] PD_H[3]
+ TIE_LO_ESD w_588_14893# sky130_fd_io__gpio_odrvr_subv2_0/m3_6107_13425# w_n915_9930#
+ sky130_fd_io__gpio_odrvr_subv2_0/li_5884_n9263# sky130_fd_io__gpio_odrvr_subv2_0/m2_8191_n10933#
+ VGND_IO sky130_fd_io__gpio_odrvr_subv2_0/sky130_fd_io__gpio_pudrvr_strongv2_0/m1_14880_n614#
+ sky130_fd_io__gpio_odrvr_subv2_0/sky130_fd_io__gpio_pudrvr_strongv2_0/li_9083_n155#
+ TIE_HI_ESD sky130_fd_io__gpio_odrvr_subv2_0/m1_2782_13727# PAD w_5497_14893# VCC_IO
+ sky130_fd_io__gpio_odrvr_subv2
.ends

.subckt sky130_fd_io__gpio_opathv2 HLD_I_H_N OD_H SLOW VPWR HLD_I_OVR_H sky130_fd_io__gpiov2_octl_dat_0/a_1528_3203#
+ sky130_fd_io__gpiov2_octl_dat_0/a_2205_3177# sky130_fd_io__gpiov2_octl_dat_0/sky130_fd_io__gpiov2_obpredrvr_0/sky130_fd_io__gpio_pupredrvr_strongv2_0/sky130_fd_io__gpiov2_pupredrvr_strong_nd2_0/a_158_632#
+ sky130_fd_io__gpiov2_octl_dat_0/sky130_fd_io__gpiov2_obpredrvr_0/sky130_fd_io__gpiov2_pdpredrvr_strong_0/sky130_fd_io__gpiov2_octl_mux_0/Y_H
+ DM_H[0] DM_H_N[0] sky130_fd_io__gpiov2_octl_dat_0/a_1106_3203# DM_H[2] DM_H_N[1]
+ m1_4747_14860# sky130_fd_io__gpio_odrvrv2_0/sky130_fd_io__gpio_odrvr_subv2_0/sky130_fd_io__gpio_pudrvr_strongv2_0/li_9083_n155#
+ TIE_LO_ESD sky130_fd_io__gpiov2_octl_dat_0/a_3125_3203# sky130_fd_io__gpiov2_octl_dat_0/a_4416_3253#
+ sky130_fd_io__gpio_odrvrv2_0/PU_H_N[2] m2_2157_n626# sky130_fd_io__gpiov2_octl_dat_0/sky130_fd_io__gpiov2_obpredrvr_0/sky130_fd_io__gpio_pupredrvr_strongv2_0/sky130_fd_io__feascom_pupredrvr_nbiasv2_0/a_2821_220#
+ TIE_HI_ESD m1_5007_14796# DM_H[1] PAD sky130_fd_io__gpiov2_octl_dat_0/sky130_fd_io__gpiov2_obpredrvr_0/sky130_fd_io__gpio_pupredrvr_strongv2_0/sky130_fd_io__feascom_pupredrvr_nbiasv2_0/a_2874_118#
+ sky130_fd_io__gpiov2_octl_dat_0/a_8354_4056# DM_H_N[2] sky130_fd_io__gpiov2_octl_dat_0/a_1415_3203#
+ VSSIO_AMX sky130_fd_io__gpiov2_octl_dat_0/a_9656_1708# VPWR_KA OE_N OUT VGND VCC_IO
+ sky130_fd_io__gpiov2_octl_dat_0/sky130_fd_io__gpiov2_obpredrvr_0/sky130_fd_io__gpio_pupredrvr_strongv2_0/sky130_fd_io__feascom_pupredrvr_nbiasv2_0/NBIAS
+ sky130_fd_io__gpiov2_octl_dat_0/sky130_fd_io__gpiov2_obpredrvr_0/sky130_fd_io__gpio_pupredrvr_strongv2_0/sky130_fd_io__feascom_pupredrvr_nbiasv2_0/a_1772_220#
+ sky130_fd_io__gpiov2_octl_dat_0/sky130_fd_io__gpiov2_obpredrvr_0/sky130_fd_io__gpio_pupredrvr_strongv2_0/sky130_fd_io__feascom_pupredrvr_nbiasv2_0/a_261_220#
+ VGND_IO
Xsky130_fd_io__gpiov2_octl_dat_0 VPWR_KA VGND SLOW HLD_I_OVR_H OD_H sky130_fd_io__gpiov2_octl_dat_0/SLOW_H_N
+ sky130_fd_io__gpiov2_octl_dat_0/DRVHI_H sky130_fd_io__gpio_odrvrv2_0/PU_H_N[2] sky130_fd_io__gpio_odrvrv2_0/PU_H_N[1]
+ sky130_fd_io__gpio_odrvrv2_0/PU_H_N[0] sky130_fd_io__gpio_odrvrv2_0/PD_H[1] sky130_fd_io__gpio_odrvrv2_0/PD_H[0]
+ sky130_fd_io__gpiov2_octl_dat_0/PD_H[4] sky130_fd_io__gpio_odrvrv2_0/PD_H[3] sky130_fd_io__gpio_odrvrv2_0/PD_H[2]
+ sky130_fd_io__gpiov2_octl_dat_0/a_1106_3203# sky130_fd_io__gpiov2_octl_dat_0/a_3125_3203#
+ sky130_fd_io__gpiov2_octl_dat_0/a_4416_3253# sky130_fd_io__gpiov2_octl_dat_0/sky130_fd_io__gpiov2_obpredrvr_0/sky130_fd_io__gpio_pupredrvr_strongv2_0/sky130_fd_io__feascom_pupredrvr_nbiasv2_0/NBIAS
+ sky130_fd_io__gpiov2_octl_dat_0/sky130_fd_io__gpiov2_obpredrvr_0/sky130_fd_io__gpio_pupredrvr_strongv2_0/sky130_fd_io__feascom_pupredrvr_nbiasv2_0/a_261_220#
+ VGND sky130_fd_io__gpiov2_octl_dat_0/a_8354_4056# sky130_fd_io__gpiov2_octl_dat_0/sky130_fd_io__gpiov2_obpredrvr_0/sky130_fd_io__gpio_pupredrvr_strongv2_0/sky130_fd_io__feascom_pupredrvr_nbiasv2_0/a_2821_220#
+ DM_H[0] sky130_fd_io__gpiov2_octl_dat_0/sky130_fd_io__gpiov2_obpredrvr_0/sky130_fd_io__gpiov2_pdpredrvr_strong_0/sky130_fd_io__gpiov2_octl_mux_0/Y_H
+ DM_H[1] DM_H_N[0] DM_H_N[1] DM_H[2] DM_H_N[2] sky130_fd_io__gpiov2_octl_dat_0/a_1415_3203#
+ sky130_fd_io__gpiov2_octl_dat_0/sky130_fd_io__gpiov2_obpredrvr_0/sky130_fd_io__gpio_pupredrvr_strongv2_0/sky130_fd_io__feascom_pupredrvr_nbiasv2_0/a_2874_118#
+ OE_N VGND sky130_fd_io__gpiov2_octl_dat_0/a_9656_1708# sky130_fd_io__gpiov2_octl_dat_0/sky130_fd_io__gpiov2_obpredrvr_0/sky130_fd_io__gpio_pupredrvr_strongv2_0/sky130_fd_io__gpiov2_pupredrvr_strong_nd2_0/a_158_632#
+ HLD_I_H_N sky130_fd_io__gpiov2_octl_dat_0/a_1528_3203# sky130_fd_io__gpiov2_octl_dat_0/a_2205_3177#
+ VGND_IO VPWR sky130_fd_io__gpiov2_octl_dat_0/sky130_fd_io__gpiov2_obpredrvr_0/sky130_fd_io__gpio_pupredrvr_strongv2_0/sky130_fd_io__feascom_pupredrvr_nbiasv2_0/a_1772_220#
+ OUT VCC_IO sky130_fd_io__gpio_odrvrv2_0/PU_H_N[3] sky130_fd_io__gpiov2_octl_dat
Xsky130_fd_io__gpio_odrvrv2_0 PAD sky130_fd_io__gpio_odrvrv2_0/PU_H_N[0] sky130_fd_io__gpio_odrvrv2_0/PU_H_N[1]
+ sky130_fd_io__gpio_odrvrv2_0/PU_H_N[2] sky130_fd_io__gpio_odrvrv2_0/PU_H_N[3] VSSIO_AMX
+ VSSIO_AMX VSSIO_AMX sky130_fd_io__gpio_odrvrv2_0/PD_H[0] sky130_fd_io__gpio_odrvrv2_0/PD_H[1]
+ sky130_fd_io__gpio_odrvrv2_0/PD_H[2] sky130_fd_io__gpio_odrvrv2_0/PD_H[3] w_n815_25161#
+ VSSIO_AMX VGND_IO TIE_LO_ESD TIE_HI_ESD VGND_IO VGND VGND VGND_IO sky130_fd_io__gpio_odrvrv2_0/sky130_fd_io__gpio_odrvr_subv2_0/sky130_fd_io__gpio_pudrvr_strongv2_0/li_9083_n155#
+ sky130_fd_io__gpio_odrvrv2_0/PU_H_N[1] sky130_fd_io__gpiov2_octl_dat_0/PD_H[4] VGND
+ VCC_IO VGND_IO sky130_fd_io__gpio_odrvrv2
.ends

.subckt sky130_fd_io__amux_switch_1v2b VSSD VDDA PAD_HV_N2 VDDIO PAD_HV_N3 AMUXBUS_HV
+ PG_AMX_VDDA_H_N NG_AMX_VPMP_H NG_PAD_VPMP_H PAD_HV_P0 PAD_HV_P1 PG_PAD_VDDIOQ_H_N
+ PAD_HV_N0 PAD_HV_N1 w_7010_315# w_3919_213#
X0 AMUXBUS_HV NG_AMX_VPMP_H w_3919_213# w_3919_213# sky130_fd_pr__nfet_g5v0d10v5 ad=1.225 pd=7.35 as=0.98 ps=7.28 w=7 l=0.5
X1 PAD_HV_N0 NG_PAD_VPMP_H w_3919_213# w_3919_213# sky130_fd_pr__nfet_g5v0d10v5 ad=1.225 pd=7.35 as=0.98 ps=7.28 w=7 l=0.5
X2 w_3919_213# PG_PAD_VDDIOQ_H_N PAD_HV_P0 VDDIO sky130_fd_pr__pfet_g5v0d10v5 ad=0.98 pd=7.28 as=1.225 ps=7.35 w=7 l=0.5
X3 PAD_HV_N1 NG_PAD_VPMP_H w_3919_213# w_3919_213# sky130_fd_pr__nfet_g5v0d10v5 ad=1.225 pd=7.35 as=0.98 ps=7.28 w=7 l=0.5
X4 w_7010_315# NG_PAD_VPMP_H PAD_HV_N2 w_7010_315# sky130_fd_pr__nfet_g5v0d10v5 ad=1.225 pd=7.35 as=0.98 ps=7.28 w=7 l=0.5
X5 AMUXBUS_HV PG_AMX_VDDA_H_N w_3919_213# VDDA sky130_fd_pr__pfet_g5v0d10v5 ad=0.98 pd=7.28 as=1.225 ps=7.35 w=7 l=0.5
X6 w_3919_213# PG_AMX_VDDA_H_N AMUXBUS_HV VDDA sky130_fd_pr__pfet_g5v0d10v5 ad=1.225 pd=7.35 as=0.98 ps=7.28 w=7 l=0.5
X7 w_3919_213# NG_PAD_VPMP_H PAD_HV_N1 w_3919_213# sky130_fd_pr__nfet_g5v0d10v5 ad=1.96 pd=14.56 as=1.225 ps=7.35 w=7 l=0.5
X8 PAD_HV_N2 NG_PAD_VPMP_H w_7010_315# w_7010_315# sky130_fd_pr__nfet_g5v0d10v5 ad=0.98 pd=7.28 as=1.225 ps=7.35 w=7 l=0.5
X9 w_3919_213# NG_AMX_VPMP_H AMUXBUS_HV w_3919_213# sky130_fd_pr__nfet_g5v0d10v5 ad=0.98 pd=7.28 as=1.225 ps=7.35 w=7 l=0.5
X10 w_3919_213# PG_AMX_VDDA_H_N AMUXBUS_HV VDDA sky130_fd_pr__pfet_g5v0d10v5 ad=1.225 pd=7.35 as=1.96 ps=14.56 w=7 l=0.5
X11 w_3919_213# NG_PAD_VPMP_H PAD_HV_N0 w_3919_213# sky130_fd_pr__nfet_g5v0d10v5 ad=0.98 pd=7.28 as=2.205 ps=14.63 w=7 l=0.5
X12 w_7010_315# NG_AMX_VPMP_H AMUXBUS_HV w_7010_315# sky130_fd_pr__nfet_g5v0d10v5 ad=1.225 pd=7.35 as=0.98 ps=7.28 w=7 l=0.5
X13 w_7010_315# NG_PAD_VPMP_H PAD_HV_N3 w_7010_315# sky130_fd_pr__nfet_g5v0d10v5 ad=1.225 pd=7.35 as=0.98 ps=7.28 w=7 l=0.5
X14 w_3919_213# NG_PAD_VPMP_H PAD_HV_N1 w_3919_213# sky130_fd_pr__nfet_g5v0d10v5 ad=0.98 pd=7.28 as=1.225 ps=7.35 w=7 l=0.5
X15 AMUXBUS_HV NG_AMX_VPMP_H w_3919_213# w_3919_213# sky130_fd_pr__nfet_g5v0d10v5 ad=1.225 pd=7.35 as=0.98 ps=7.28 w=7 l=0.5
X16 AMUXBUS_HV NG_AMX_VPMP_H w_3919_213# w_3919_213# sky130_fd_pr__nfet_g5v0d10v5 ad=2.205 pd=14.63 as=0.98 ps=7.28 w=7 l=0.5
X17 w_3919_213# PG_PAD_VDDIOQ_H_N PAD_HV_P0 VDDIO sky130_fd_pr__pfet_g5v0d10v5 ad=0.98 pd=7.28 as=2.205 ps=14.63 w=7 l=0.5
X18 w_7010_315# NG_AMX_VPMP_H AMUXBUS_HV w_7010_315# sky130_fd_pr__nfet_g5v0d10v5 ad=1.225 pd=7.35 as=0.98 ps=7.28 w=7 l=0.5
X19 AMUXBUS_HV PG_AMX_VDDA_H_N w_3919_213# VDDA sky130_fd_pr__pfet_g5v0d10v5 ad=0.98 pd=7.28 as=1.225 ps=7.35 w=7 l=0.5
X20 AMUXBUS_HV NG_AMX_VPMP_H w_3919_213# w_3919_213# sky130_fd_pr__nfet_g5v0d10v5 ad=1.225 pd=7.35 as=1.96 ps=14.56 w=7 l=0.5
X21 PAD_HV_N3 NG_PAD_VPMP_H w_7010_315# w_7010_315# sky130_fd_pr__nfet_g5v0d10v5 ad=0.98 pd=7.28 as=1.225 ps=7.35 w=7 l=0.5
X22 PAD_HV_P1 PG_PAD_VDDIOQ_H_N w_3919_213# VDDIO sky130_fd_pr__pfet_g5v0d10v5 ad=2.205 pd=14.63 as=0.98 ps=7.28 w=7 l=0.5
X23 PAD_HV_P1 PG_PAD_VDDIOQ_H_N w_3919_213# VDDIO sky130_fd_pr__pfet_g5v0d10v5 ad=1.225 pd=7.35 as=0.98 ps=7.28 w=7 l=0.5
X24 PAD_HV_N2 NG_PAD_VPMP_H w_7010_315# w_7010_315# sky130_fd_pr__nfet_g5v0d10v5 ad=0.98 pd=7.28 as=2.205 ps=14.63 w=7 l=0.5
X25 AMUXBUS_HV NG_AMX_VPMP_H w_7010_315# w_7010_315# sky130_fd_pr__nfet_g5v0d10v5 ad=0.98 pd=7.28 as=1.225 ps=7.35 w=7 l=0.5
X26 PAD_HV_N3 NG_PAD_VPMP_H w_7010_315# w_7010_315# sky130_fd_pr__nfet_g5v0d10v5 ad=0.98 pd=7.28 as=1.225 ps=7.35 w=7 l=0.5
X27 w_3919_213# NG_AMX_VPMP_H AMUXBUS_HV w_3919_213# sky130_fd_pr__nfet_g5v0d10v5 ad=0.98 pd=7.28 as=1.225 ps=7.35 w=7 l=0.5
X28 PAD_HV_N1 NG_PAD_VPMP_H w_3919_213# w_3919_213# sky130_fd_pr__nfet_g5v0d10v5 ad=1.225 pd=7.35 as=0.98 ps=7.28 w=7 l=0.5
X29 w_7010_315# NG_PAD_VPMP_H PAD_HV_N2 w_7010_315# sky130_fd_pr__nfet_g5v0d10v5 ad=1.225 pd=7.35 as=0.98 ps=7.28 w=7 l=0.5
X30 w_7010_315# NG_AMX_VPMP_H AMUXBUS_HV w_7010_315# sky130_fd_pr__nfet_g5v0d10v5 ad=2.205 pd=14.63 as=0.98 ps=7.28 w=7 l=0.5
X31 w_7010_315# NG_AMX_VPMP_H AMUXBUS_HV w_7010_315# sky130_fd_pr__nfet_g5v0d10v5 ad=1.225 pd=7.35 as=1.96 ps=14.56 w=7 l=0.5
X32 w_3919_213# PG_PAD_VDDIOQ_H_N PAD_HV_P1 VDDIO sky130_fd_pr__pfet_g5v0d10v5 ad=0.98 pd=7.28 as=1.225 ps=7.35 w=7 l=0.5
X33 w_3919_213# PG_AMX_VDDA_H_N AMUXBUS_HV VDDA sky130_fd_pr__pfet_g5v0d10v5 ad=2.205 pd=14.63 as=0.98 ps=7.28 w=7 l=0.5
X34 PAD_HV_P0 PG_PAD_VDDIOQ_H_N w_3919_213# VDDIO sky130_fd_pr__pfet_g5v0d10v5 ad=1.225 pd=7.35 as=0.98 ps=7.28 w=7 l=0.5
X35 w_3919_213# NG_AMX_VPMP_H AMUXBUS_HV w_3919_213# sky130_fd_pr__nfet_g5v0d10v5 ad=0.98 pd=7.28 as=1.225 ps=7.35 w=7 l=0.5
X36 w_3919_213# NG_PAD_VPMP_H PAD_HV_N0 w_3919_213# sky130_fd_pr__nfet_g5v0d10v5 ad=0.98 pd=7.28 as=1.225 ps=7.35 w=7 l=0.5
X37 AMUXBUS_HV NG_AMX_VPMP_H w_7010_315# w_7010_315# sky130_fd_pr__nfet_g5v0d10v5 ad=0.98 pd=7.28 as=1.225 ps=7.35 w=7 l=0.5
X38 AMUXBUS_HV NG_AMX_VPMP_H w_7010_315# w_7010_315# sky130_fd_pr__nfet_g5v0d10v5 ad=0.98 pd=7.28 as=1.225 ps=7.35 w=7 l=0.5
X39 w_7010_315# NG_PAD_VPMP_H PAD_HV_N3 w_7010_315# sky130_fd_pr__nfet_g5v0d10v5 ad=2.205 pd=14.63 as=0.98 ps=7.28 w=7 l=0.5
.ends

.subckt sky130_fd_io__res75only_small PAD ROUT
X0 PAD ROUT sky130_fd_pr__res_generic_po w=2 l=3.15
.ends

.subckt sky130_fd_io__inv_1 VPWR VGND Y A VNB VPB
X0 Y A VPWR VPB sky130_fd_pr__pfet_01v8_hvt ad=0.3304 pd=2.83 as=0.3864 ps=2.93 w=1.12 l=0.15
X1 Y A VGND VNB sky130_fd_pr__nfet_01v8 ad=0.2109 pd=2.05 as=0.2627 ps=2.19 w=0.74 l=0.15
.ends

.subckt sky130_fd_io__nor2_1 vgnd vpwr A Y B vnb vpb
X0 a_116_368# A vpwr vpb sky130_fd_pr__pfet_01v8_hvt ad=0.1512 pd=1.39 as=0.3304 ps=2.83 w=1.12 l=0.15
X1 Y A vgnd vnb sky130_fd_pr__nfet_01v8 ad=0.1036 pd=1.02 as=0.2109 ps=2.05 w=0.74 l=0.15
X2 Y B a_116_368# vpb sky130_fd_pr__pfet_01v8_hvt ad=0.3304 pd=2.83 as=0.1512 ps=1.39 w=1.12 l=0.15
X3 vgnd B Y vnb sky130_fd_pr__nfet_01v8 ad=0.2109 pd=2.05 as=0.1036 ps=1.02 w=0.74 l=0.15
.ends

.subckt sky130_fd_io__nand2_1 B Y A VPWR VGND VNB VPB
X0 a_117_74# B VGND VNB sky130_fd_pr__nfet_01v8 ad=0.0888 pd=0.98 as=0.2109 ps=2.05 w=0.74 l=0.15
X1 VPWR A Y VPB sky130_fd_pr__pfet_01v8_hvt ad=0.3192 pd=2.81 as=0.168 ps=1.42 w=1.12 l=0.15
X2 Y A a_117_74# VNB sky130_fd_pr__nfet_01v8 ad=0.2109 pd=2.05 as=0.0888 ps=0.98 w=0.74 l=0.15
X3 Y B VPWR VPB sky130_fd_pr__pfet_01v8_hvt ad=0.168 pd=1.42 as=0.3192 ps=2.81 w=1.12 l=0.15
.ends

.subckt sky130_fd_io__gpiov2_amux_decoder sky130_fd_io__inv_1_8/A sky130_fd_io__inv_1_0/Y
+ sky130_fd_io__inv_1_11/A sky130_fd_io__inv_1_2/Y sky130_fd_io__inv_1_13/A sky130_fd_io__nor2_1_0/Y
+ sky130_fd_io__inv_1_4/Y sky130_fd_io__nand2_1_0/Y sky130_fd_io__inv_1_1/A sky130_fd_io__nor2_1_2/Y
+ sky130_fd_io__nand2_1_2/Y sky130_fd_io__inv_1_6/Y sky130_fd_io__inv_1_3/A sky130_fd_io__nor2_1_1/B
+ sky130_fd_io__inv_1_8/Y sky130_fd_io__nand2_1_1/B sky130_fd_io__nor2_1_1/A sky130_fd_io__inv_1_11/Y
+ sky130_fd_io__inv_1_5/A sky130_fd_io__nand2_1_1/A sky130_fd_io__nor2_1_3/B sky130_fd_io__nor2_1_3/A
+ sky130_fd_io__inv_1_13/Y sky130_fd_io__nand2_1_3/B sky130_fd_io__inv_1_7/A sky130_fd_io__inv_1_10/A
+ sky130_fd_io__nand2_1_3/A sky130_fd_io__inv_1_1/Y sky130_fd_io__inv_1_12/A sky130_fd_io__inv_1_9/A
+ sky130_fd_io__inv_1_8/VGND sky130_fd_io__inv_1_3/Y sky130_fd_io__inv_1_14/A sky130_fd_io__inv_1_0/A
+ sky130_fd_io__nor2_1_1/Y sky130_fd_io__nand2_1_1/Y sky130_fd_io__inv_1_5/Y sky130_fd_io__nor2_1_0/B
+ sky130_fd_io__nor2_1_3/Y sky130_fd_io__inv_1_2/A sky130_fd_io__nor2_1_0/A sky130_fd_io__inv_1_7/Y
+ sky130_fd_io__tap_1_2/VGND sky130_fd_io__nand2_1_3/Y sky130_fd_io__inv_1_10/Y sky130_fd_io__nand2_1_0/B
+ sky130_fd_io__inv_1_4/A sky130_fd_io__nand2_1_0/A sky130_fd_io__nor2_1_2/B sky130_fd_io__inv_1_9/Y
+ sky130_fd_io__nor2_1_2/A sky130_fd_io__inv_1_12/Y sky130_fd_io__inv_1_6/A sky130_fd_io__nand2_1_2/B
+ sky130_fd_io__nand2_1_2/A sky130_fd_io__tap_1_2/VPWR sky130_fd_io__tap_1_1/VGND
+ VSUBS sky130_fd_io__inv_1_14/Y sky130_fd_io__tap_1_2/VPB
Xsky130_fd_io__inv_1_10 sky130_fd_io__tap_1_2/VPWR sky130_fd_io__tap_1_2/VGND sky130_fd_io__inv_1_10/Y
+ sky130_fd_io__inv_1_10/A VSUBS sky130_fd_io__tap_1_2/VPB sky130_fd_io__inv_1
Xsky130_fd_io__inv_1_11 sky130_fd_io__tap_1_2/VPWR sky130_fd_io__tap_1_2/VGND sky130_fd_io__inv_1_11/Y
+ sky130_fd_io__inv_1_11/A VSUBS sky130_fd_io__tap_1_2/VPB sky130_fd_io__inv_1
Xsky130_fd_io__inv_1_12 sky130_fd_io__tap_1_2/VPWR sky130_fd_io__inv_1_8/VGND sky130_fd_io__inv_1_12/Y
+ sky130_fd_io__inv_1_12/A VSUBS sky130_fd_io__tap_1_2/VPB sky130_fd_io__inv_1
Xsky130_fd_io__inv_1_13 sky130_fd_io__tap_1_2/VPWR sky130_fd_io__inv_1_8/VGND sky130_fd_io__inv_1_13/Y
+ sky130_fd_io__inv_1_13/A VSUBS sky130_fd_io__tap_1_2/VPB sky130_fd_io__inv_1
Xsky130_fd_io__inv_1_14 sky130_fd_io__tap_1_2/VPWR sky130_fd_io__tap_1_1/VGND sky130_fd_io__inv_1_14/Y
+ sky130_fd_io__inv_1_14/A VSUBS sky130_fd_io__tap_1_2/VPB sky130_fd_io__inv_1
Xsky130_fd_io__inv_1_0 sky130_fd_io__tap_1_2/VPWR sky130_fd_io__tap_1_1/VGND sky130_fd_io__inv_1_0/Y
+ sky130_fd_io__inv_1_0/A VSUBS sky130_fd_io__tap_1_2/VPB sky130_fd_io__inv_1
Xsky130_fd_io__inv_1_1 sky130_fd_io__tap_1_2/VPWR sky130_fd_io__tap_1_1/VGND sky130_fd_io__inv_1_1/Y
+ sky130_fd_io__inv_1_1/A VSUBS sky130_fd_io__tap_1_2/VPB sky130_fd_io__inv_1
Xsky130_fd_io__inv_1_2 sky130_fd_io__tap_1_2/VPWR sky130_fd_io__tap_1_1/VGND sky130_fd_io__inv_1_2/Y
+ sky130_fd_io__inv_1_2/A VSUBS sky130_fd_io__tap_1_2/VPB sky130_fd_io__inv_1
Xsky130_fd_io__inv_1_3 sky130_fd_io__tap_1_2/VPWR sky130_fd_io__tap_1_1/VGND sky130_fd_io__inv_1_3/Y
+ sky130_fd_io__inv_1_3/A VSUBS sky130_fd_io__tap_1_2/VPB sky130_fd_io__inv_1
Xsky130_fd_io__inv_1_4 sky130_fd_io__tap_1_2/VPWR sky130_fd_io__tap_1_1/VGND sky130_fd_io__inv_1_4/Y
+ sky130_fd_io__inv_1_4/A VSUBS sky130_fd_io__tap_1_2/VPB sky130_fd_io__inv_1
Xsky130_fd_io__inv_1_5 sky130_fd_io__tap_1_2/VPWR sky130_fd_io__tap_1_2/VGND sky130_fd_io__inv_1_5/Y
+ sky130_fd_io__inv_1_5/A VSUBS sky130_fd_io__tap_1_2/VPB sky130_fd_io__inv_1
Xsky130_fd_io__inv_1_6 sky130_fd_io__tap_1_2/VPWR sky130_fd_io__tap_1_1/VGND sky130_fd_io__inv_1_6/Y
+ sky130_fd_io__inv_1_6/A VSUBS sky130_fd_io__tap_1_2/VPB sky130_fd_io__inv_1
Xsky130_fd_io__nor2_1_0 sky130_fd_io__tap_1_1/VGND sky130_fd_io__tap_1_2/VPWR sky130_fd_io__nor2_1_0/A
+ sky130_fd_io__nor2_1_0/Y sky130_fd_io__nor2_1_0/B VSUBS sky130_fd_io__tap_1_2/VPB
+ sky130_fd_io__nor2_1
Xsky130_fd_io__inv_1_7 sky130_fd_io__tap_1_2/VPWR sky130_fd_io__tap_1_2/VGND sky130_fd_io__inv_1_7/Y
+ sky130_fd_io__inv_1_7/A VSUBS sky130_fd_io__tap_1_2/VPB sky130_fd_io__inv_1
Xsky130_fd_io__nor2_1_2 sky130_fd_io__tap_1_1/VGND sky130_fd_io__tap_1_2/VPWR sky130_fd_io__nor2_1_2/A
+ sky130_fd_io__nor2_1_2/Y sky130_fd_io__nor2_1_2/B VSUBS sky130_fd_io__tap_1_2/VPB
+ sky130_fd_io__nor2_1
Xsky130_fd_io__nor2_1_1 sky130_fd_io__tap_1_1/VGND sky130_fd_io__tap_1_2/VPWR sky130_fd_io__nor2_1_1/A
+ sky130_fd_io__nor2_1_1/Y sky130_fd_io__nor2_1_1/B VSUBS sky130_fd_io__tap_1_2/VPB
+ sky130_fd_io__nor2_1
Xsky130_fd_io__nor2_1_3 sky130_fd_io__tap_1_1/VGND sky130_fd_io__tap_1_2/VPWR sky130_fd_io__nor2_1_3/A
+ sky130_fd_io__nor2_1_3/Y sky130_fd_io__nor2_1_3/B VSUBS sky130_fd_io__tap_1_2/VPB
+ sky130_fd_io__nor2_1
Xsky130_fd_io__inv_1_8 sky130_fd_io__tap_1_2/VPWR sky130_fd_io__inv_1_8/VGND sky130_fd_io__inv_1_8/Y
+ sky130_fd_io__inv_1_8/A VSUBS sky130_fd_io__tap_1_2/VPB sky130_fd_io__inv_1
Xsky130_fd_io__inv_1_9 sky130_fd_io__tap_1_2/VPWR sky130_fd_io__tap_1_2/VGND sky130_fd_io__inv_1_9/Y
+ sky130_fd_io__inv_1_9/A VSUBS sky130_fd_io__tap_1_2/VPB sky130_fd_io__inv_1
Xsky130_fd_io__nand2_1_0 sky130_fd_io__nand2_1_0/B sky130_fd_io__nand2_1_0/Y sky130_fd_io__nand2_1_0/A
+ sky130_fd_io__tap_1_2/VPWR sky130_fd_io__tap_1_2/VGND VSUBS sky130_fd_io__tap_1_2/VPB
+ sky130_fd_io__nand2_1
Xsky130_fd_io__nand2_1_1 sky130_fd_io__nand2_1_1/B sky130_fd_io__nand2_1_1/Y sky130_fd_io__nand2_1_1/A
+ sky130_fd_io__tap_1_2/VPWR sky130_fd_io__inv_1_8/VGND VSUBS sky130_fd_io__tap_1_2/VPB
+ sky130_fd_io__nand2_1
Xsky130_fd_io__nand2_1_2 sky130_fd_io__nand2_1_2/B sky130_fd_io__nand2_1_2/Y sky130_fd_io__nand2_1_2/A
+ sky130_fd_io__tap_1_2/VPWR sky130_fd_io__tap_1_2/VGND VSUBS sky130_fd_io__tap_1_2/VPB
+ sky130_fd_io__nand2_1
Xsky130_fd_io__nand2_1_3 sky130_fd_io__nand2_1_3/B sky130_fd_io__nand2_1_3/Y sky130_fd_io__nand2_1_3/A
+ sky130_fd_io__tap_1_2/VPWR sky130_fd_io__tap_1_2/VGND VSUBS sky130_fd_io__tap_1_2/VPB
+ sky130_fd_io__nand2_1
.ends

.subckt sky130_fd_io__gpiov2_amux_ctl_logic sky130_fd_io__gpiov2_amux_decoder_0/sky130_fd_io__inv_1_4/A
+ sky130_fd_io__gpiov2_amux_decoder_0/sky130_fd_io__inv_1_9/Y sky130_fd_io__gpiov2_amux_decoder_0/sky130_fd_io__nor2_1_2/Y
+ sky130_fd_io__gpiov2_amux_decoder_0/sky130_fd_io__inv_1_6/A sky130_fd_io__gpiov2_amux_decoder_0/sky130_fd_io__nand2_1_1/Y
+ sky130_fd_io__gpiov2_amux_decoder_0/sky130_fd_io__nor2_1_1/B sky130_fd_io__gpiov2_amux_decoder_0/sky130_fd_io__inv_1_0/Y
+ sky130_fd_io__gpiov2_amux_decoder_0/sky130_fd_io__inv_1_8/A sky130_fd_io__gpiov2_amux_decoder_0/sky130_fd_io__nor2_1_1/A
+ sky130_fd_io__gpiov2_amux_decoder_0/sky130_fd_io__nand2_1_3/Y sky130_fd_io__gpiov2_amux_decoder_0/sky130_fd_io__inv_1_11/Y
+ sky130_fd_io__gpiov2_amux_decoder_0/sky130_fd_io__nand2_1_0/B sky130_fd_io__gpiov2_amux_decoder_0/sky130_fd_io__nor2_1_3/B
+ sky130_fd_io__gpiov2_amux_decoder_0/sky130_fd_io__nand2_1_0/A sky130_fd_io__gpiov2_amux_decoder_0/sky130_fd_io__inv_1_2/Y
+ sky130_fd_io__gpiov2_amux_decoder_0/sky130_fd_io__nor2_1_3/A sky130_fd_io__gpiov2_amux_decoder_0/sky130_fd_io__inv_1_13/Y
+ sky130_fd_io__gpiov2_amux_decoder_0/sky130_fd_io__nand2_1_2/B sky130_fd_io__gpiov2_amux_decoder_0/sky130_fd_io__inv_1_10/A
+ sky130_fd_io__gpiov2_amux_decoder_0/sky130_fd_io__inv_1_4/Y sky130_fd_io__gpiov2_amux_decoder_0/sky130_fd_io__nand2_1_2/A
+ sky130_fd_io__gpiov2_amux_decoder_0/sky130_fd_io__inv_1_1/A sky130_fd_io__gpiov2_amux_decoder_0/sky130_fd_io__inv_1_12/A
+ sky130_fd_io__gpiov2_amux_decoder_0/sky130_fd_io__inv_1_6/Y sky130_fd_io__gpiov2_amux_decoder_0/sky130_fd_io__inv_1_3/A
+ sky130_fd_io__gpiov2_amux_decoder_0/sky130_fd_io__inv_1_14/A sky130_fd_io__gpiov2_amux_decoder_0/sky130_fd_io__inv_1_8/Y
+ sky130_fd_io__gpiov2_amux_decoder_0/sky130_fd_io__nor2_1_1/Y sky130_fd_io__gpiov2_amux_decoder_0/sky130_fd_io__inv_1_5/A
+ sky130_fd_io__gpiov2_amux_decoder_0/sky130_fd_io__nand2_1_0/Y sky130_fd_io__gpiov2_amux_decoder_0/sky130_fd_io__nor2_1_0/B
+ sky130_fd_io__gpiov2_amux_decoder_0/sky130_fd_io__nor2_1_3/Y sky130_fd_io__gpiov2_amux_ls_0/sky130_fd_io__tap_1_0/VPWR
+ sky130_fd_io__gpiov2_amux_decoder_0/sky130_fd_io__inv_1_10/Y sky130_fd_io__gpiov2_amux_decoder_0/sky130_fd_io__inv_1_7/A
+ sky130_fd_io__gpiov2_amux_decoder_0/sky130_fd_io__nor2_1_0/A sky130_fd_io__gpiov2_amux_decoder_0/sky130_fd_io__nand2_1_2/Y
+ sky130_fd_io__gpiov2_amux_decoder_0/sky130_fd_io__inv_1_1/Y sky130_fd_io__gpiov2_amux_decoder_0/sky130_fd_io__nor2_1_2/B
+ sky130_fd_io__gpiov2_amux_decoder_0/sky130_fd_io__inv_1_9/A sky130_fd_io__gpiov2_amux_decoder_0/sky130_fd_io__nor2_1_2/A
+ sky130_fd_io__gpiov2_amux_decoder_0/sky130_fd_io__inv_1_12/Y sky130_fd_io__gpiov2_amux_decoder_0/sky130_fd_io__nand2_1_1/B
+ sky130_fd_io__gpiov2_amux_decoder_0/sky130_fd_io__nand2_1_1/A sky130_fd_io__gpiov2_amux_decoder_0/sky130_fd_io__inv_1_3/Y
+ sky130_fd_io__gpiov2_amux_decoder_0/sky130_fd_io__inv_1_14/Y sky130_fd_io__gpiov2_amux_decoder_0/sky130_fd_io__inv_1_0/A
+ sky130_fd_io__gpiov2_amux_decoder_0/sky130_fd_io__tap_1_2/VPB sky130_fd_io__gpiov2_amux_decoder_0/sky130_fd_io__inv_1_11/A
+ sky130_fd_io__gpiov2_amux_decoder_0/sky130_fd_io__nand2_1_3/B sky130_fd_io__gpiov2_amux_decoder_0/sky130_fd_io__inv_1_5/Y
+ sky130_fd_io__gpiov2_amux_ls_0/sky130_fd_io__tap_1_0/VPB sky130_fd_io__gpiov2_amux_ls_0/sky130_fd_io__tap_1_0/VGND
+ sky130_fd_io__gpiov2_amux_decoder_0/sky130_fd_io__tap_1_1/VGND sky130_fd_io__gpiov2_amux_decoder_0/sky130_fd_io__inv_1_8/VGND
+ sky130_fd_io__gpiov2_amux_decoder_0/sky130_fd_io__nand2_1_3/A sky130_fd_io__gpiov2_amux_decoder_0/sky130_fd_io__tap_1_2/VPWR
+ sky130_fd_io__gpiov2_amux_decoder_0/sky130_fd_io__inv_1_2/A VSUBS sky130_fd_io__gpiov2_amux_decoder_0/sky130_fd_io__inv_1_13/A
+ sky130_fd_io__gpiov2_amux_decoder_0/sky130_fd_io__inv_1_7/Y sky130_fd_io__gpiov2_amux_decoder_0/sky130_fd_io__nor2_1_0/Y
+ sky130_fd_io__gpiov2_amux_decoder_0/sky130_fd_io__tap_1_2/VGND
Xsky130_fd_io__gpiov2_amux_decoder_0 sky130_fd_io__gpiov2_amux_decoder_0/sky130_fd_io__inv_1_8/A
+ sky130_fd_io__gpiov2_amux_decoder_0/sky130_fd_io__inv_1_0/Y sky130_fd_io__gpiov2_amux_decoder_0/sky130_fd_io__inv_1_11/A
+ sky130_fd_io__gpiov2_amux_decoder_0/sky130_fd_io__inv_1_2/Y sky130_fd_io__gpiov2_amux_decoder_0/sky130_fd_io__inv_1_13/A
+ sky130_fd_io__gpiov2_amux_decoder_0/sky130_fd_io__nor2_1_0/Y sky130_fd_io__gpiov2_amux_decoder_0/sky130_fd_io__inv_1_4/Y
+ sky130_fd_io__gpiov2_amux_decoder_0/sky130_fd_io__nand2_1_0/Y sky130_fd_io__gpiov2_amux_decoder_0/sky130_fd_io__inv_1_1/A
+ sky130_fd_io__gpiov2_amux_decoder_0/sky130_fd_io__nor2_1_2/Y sky130_fd_io__gpiov2_amux_decoder_0/sky130_fd_io__nand2_1_2/Y
+ sky130_fd_io__gpiov2_amux_decoder_0/sky130_fd_io__inv_1_6/Y sky130_fd_io__gpiov2_amux_decoder_0/sky130_fd_io__inv_1_3/A
+ sky130_fd_io__gpiov2_amux_decoder_0/sky130_fd_io__nor2_1_1/B sky130_fd_io__gpiov2_amux_decoder_0/sky130_fd_io__inv_1_8/Y
+ sky130_fd_io__gpiov2_amux_decoder_0/sky130_fd_io__nand2_1_1/B sky130_fd_io__gpiov2_amux_decoder_0/sky130_fd_io__nor2_1_1/A
+ sky130_fd_io__gpiov2_amux_decoder_0/sky130_fd_io__inv_1_11/Y sky130_fd_io__gpiov2_amux_decoder_0/sky130_fd_io__inv_1_5/A
+ sky130_fd_io__gpiov2_amux_decoder_0/sky130_fd_io__nand2_1_1/A sky130_fd_io__gpiov2_amux_decoder_0/sky130_fd_io__nor2_1_3/B
+ sky130_fd_io__gpiov2_amux_decoder_0/sky130_fd_io__nor2_1_3/A sky130_fd_io__gpiov2_amux_decoder_0/sky130_fd_io__inv_1_13/Y
+ sky130_fd_io__gpiov2_amux_decoder_0/sky130_fd_io__nand2_1_3/B sky130_fd_io__gpiov2_amux_decoder_0/sky130_fd_io__inv_1_7/A
+ sky130_fd_io__gpiov2_amux_decoder_0/sky130_fd_io__inv_1_10/A sky130_fd_io__gpiov2_amux_decoder_0/sky130_fd_io__nand2_1_3/A
+ sky130_fd_io__gpiov2_amux_decoder_0/sky130_fd_io__inv_1_1/Y sky130_fd_io__gpiov2_amux_decoder_0/sky130_fd_io__inv_1_12/A
+ sky130_fd_io__gpiov2_amux_decoder_0/sky130_fd_io__inv_1_9/A sky130_fd_io__gpiov2_amux_decoder_0/sky130_fd_io__inv_1_8/VGND
+ sky130_fd_io__gpiov2_amux_decoder_0/sky130_fd_io__inv_1_3/Y sky130_fd_io__gpiov2_amux_decoder_0/sky130_fd_io__inv_1_14/A
+ sky130_fd_io__gpiov2_amux_decoder_0/sky130_fd_io__inv_1_0/A sky130_fd_io__gpiov2_amux_decoder_0/sky130_fd_io__nor2_1_1/Y
+ sky130_fd_io__gpiov2_amux_decoder_0/sky130_fd_io__nand2_1_1/Y sky130_fd_io__gpiov2_amux_decoder_0/sky130_fd_io__inv_1_5/Y
+ sky130_fd_io__gpiov2_amux_decoder_0/sky130_fd_io__nor2_1_0/B sky130_fd_io__gpiov2_amux_decoder_0/sky130_fd_io__nor2_1_3/Y
+ sky130_fd_io__gpiov2_amux_decoder_0/sky130_fd_io__inv_1_2/A sky130_fd_io__gpiov2_amux_decoder_0/sky130_fd_io__nor2_1_0/A
+ sky130_fd_io__gpiov2_amux_decoder_0/sky130_fd_io__inv_1_7/Y sky130_fd_io__gpiov2_amux_decoder_0/sky130_fd_io__tap_1_2/VGND
+ sky130_fd_io__gpiov2_amux_decoder_0/sky130_fd_io__nand2_1_3/Y sky130_fd_io__gpiov2_amux_decoder_0/sky130_fd_io__inv_1_10/Y
+ sky130_fd_io__gpiov2_amux_decoder_0/sky130_fd_io__nand2_1_0/B sky130_fd_io__gpiov2_amux_decoder_0/sky130_fd_io__inv_1_4/A
+ sky130_fd_io__gpiov2_amux_decoder_0/sky130_fd_io__nand2_1_0/A sky130_fd_io__gpiov2_amux_decoder_0/sky130_fd_io__nor2_1_2/B
+ sky130_fd_io__gpiov2_amux_decoder_0/sky130_fd_io__inv_1_9/Y sky130_fd_io__gpiov2_amux_decoder_0/sky130_fd_io__nor2_1_2/A
+ sky130_fd_io__gpiov2_amux_decoder_0/sky130_fd_io__inv_1_12/Y sky130_fd_io__gpiov2_amux_decoder_0/sky130_fd_io__inv_1_6/A
+ sky130_fd_io__gpiov2_amux_decoder_0/sky130_fd_io__nand2_1_2/B sky130_fd_io__gpiov2_amux_decoder_0/sky130_fd_io__nand2_1_2/A
+ sky130_fd_io__gpiov2_amux_decoder_0/sky130_fd_io__tap_1_2/VPWR sky130_fd_io__gpiov2_amux_decoder_0/sky130_fd_io__tap_1_1/VGND
+ VSUBS sky130_fd_io__gpiov2_amux_decoder_0/sky130_fd_io__inv_1_14/Y sky130_fd_io__gpiov2_amux_decoder_0/sky130_fd_io__tap_1_2/VPB
+ sky130_fd_io__gpiov2_amux_decoder
.ends

.subckt sky130_fd_io__gpiov2_amux sky130_fd_io__gpiov2_amux_ctl_logic_0/sky130_fd_io__gpiov2_amux_decoder_0/sky130_fd_io__nand2_1_0/Y
+ sky130_fd_io__gpiov2_amux_ctl_logic_0/sky130_fd_io__gpiov2_amux_decoder_0/sky130_fd_io__inv_1_9/Y
+ sky130_fd_io__amux_switch_1v2b_0/PAD_HV_P0 sky130_fd_io__gpiov2_amux_ctl_logic_0/sky130_fd_io__gpiov2_amux_decoder_0/sky130_fd_io__nor2_1_3/A
+ sky130_fd_io__gpiov2_amux_ctl_logic_0/sky130_fd_io__gpiov2_amux_decoder_0/sky130_fd_io__inv_1_13/Y
+ sky130_fd_io__res75only_small_0/ROUT sky130_fd_io__gpiov2_amux_ctl_logic_0/sky130_fd_io__gpiov2_amux_decoder_0/sky130_fd_io__inv_1_6/A
+ sky130_fd_io__gpiov2_amux_ctl_logic_0/sky130_fd_io__gpiov2_amux_decoder_0/sky130_fd_io__inv_1_10/A
+ sky130_fd_io__gpiov2_amux_ctl_logic_0/sky130_fd_io__gpiov2_amux_decoder_0/sky130_fd_io__nand2_1_2/Y
+ sky130_fd_io__gpiov2_amux_ctl_logic_0/sky130_fd_io__gpiov2_amux_decoder_0/sky130_fd_io__inv_1_0/Y
+ sky130_fd_io__amux_switch_1v2b_1/PAD_HV_N3 sky130_fd_io__gpiov2_amux_ctl_logic_0/sky130_fd_io__gpiov2_amux_decoder_0/sky130_fd_io__inv_1_8/A
+ sky130_fd_io__gpiov2_amux_ctl_logic_0/sky130_fd_io__gpiov2_amux_decoder_0/sky130_fd_io__inv_1_12/A
+ sky130_fd_io__amux_switch_1v2b_1/PAD_HV_N2 sky130_fd_io__amux_switch_1v2b_1/PG_AMX_VDDA_H_N
+ sky130_fd_io__amux_switch_1v2b_1/PAD_HV_N1 sky130_fd_io__res75only_small_7/ROUT
+ sky130_fd_io__amux_switch_1v2b_0/NG_PAD_VPMP_H sky130_fd_io__gpiov2_amux_ctl_logic_0/sky130_fd_io__gpiov2_amux_decoder_0/sky130_fd_io__inv_1_2/Y
+ sky130_fd_io__amux_switch_1v2b_1/PAD_HV_N0 sky130_fd_io__gpiov2_amux_ctl_logic_0/sky130_fd_io__gpiov2_amux_decoder_0/sky130_fd_io__nand2_1_1/B
+ sky130_fd_io__amux_switch_1v2b_0/NG_AMX_VPMP_H sky130_fd_io__gpiov2_amux_ctl_logic_0/sky130_fd_io__gpiov2_amux_decoder_0/sky130_fd_io__nand2_1_1/A
+ sky130_fd_io__amux_switch_1v2b_1/PAD_HV_P1 sky130_fd_io__gpiov2_amux_ctl_logic_0/sky130_fd_io__gpiov2_amux_decoder_0/sky130_fd_io__inv_1_14/A
+ sky130_fd_io__amux_switch_1v2b_1/PAD_HV_P0 sky130_fd_io__res75only_small_13/PAD
+ sky130_fd_io__gpiov2_amux_ctl_logic_0/sky130_fd_io__gpiov2_amux_decoder_0/sky130_fd_io__nor2_1_1/Y
+ sky130_fd_io__res75only_small_4/ROUT sky130_fd_io__gpiov2_amux_ctl_logic_0/sky130_fd_io__gpiov2_amux_decoder_0/sky130_fd_io__nand2_1_3/B
+ sky130_fd_io__gpiov2_amux_ctl_logic_0/sky130_fd_io__gpiov2_amux_decoder_0/sky130_fd_io__inv_1_4/Y
+ sky130_fd_io__gpiov2_amux_ctl_logic_0/sky130_fd_io__gpiov2_amux_decoder_0/sky130_fd_io__nand2_1_3/A
+ sky130_fd_io__gpiov2_amux_ctl_logic_0/sky130_fd_io__gpiov2_amux_decoder_0/sky130_fd_io__inv_1_1/A
+ sky130_fd_io__gpiov2_amux_ctl_logic_0/sky130_fd_io__gpiov2_amux_decoder_0/sky130_fd_io__nor2_1_3/Y
+ sky130_fd_io__gpiov2_amux_ctl_logic_0/sky130_fd_io__gpiov2_amux_decoder_0/sky130_fd_io__nor2_1_0/B
+ sky130_fd_io__amux_switch_1v2b_0/PG_AMX_VDDA_H_N sky130_fd_io__res75only_small_2/PAD
+ sky130_fd_io__gpiov2_amux_ctl_logic_0/sky130_fd_io__gpiov2_amux_decoder_0/sky130_fd_io__inv_1_6/Y
+ sky130_fd_io__gpiov2_amux_ctl_logic_0/sky130_fd_io__gpiov2_amux_decoder_0/sky130_fd_io__nor2_1_0/A
+ sky130_fd_io__gpiov2_amux_ctl_logic_0/sky130_fd_io__gpiov2_amux_decoder_0/sky130_fd_io__inv_1_10/Y
+ sky130_fd_io__amux_switch_1v2b_1/PG_PAD_VDDIOQ_H_N sky130_fd_io__gpiov2_amux_ctl_logic_0/sky130_fd_io__gpiov2_amux_decoder_0/sky130_fd_io__inv_1_3/A
+ sky130_fd_io__gpiov2_amux_ctl_logic_0/sky130_fd_io__gpiov2_amux_decoder_0/sky130_fd_io__nor2_1_2/B
+ sky130_fd_io__gpiov2_amux_ctl_logic_0/sky130_fd_io__gpiov2_amux_decoder_0/sky130_fd_io__inv_1_8/Y
+ sky130_fd_io__gpiov2_amux_ctl_logic_0/sky130_fd_io__gpiov2_amux_decoder_0/sky130_fd_io__nor2_1_2/A
+ sky130_fd_io__gpiov2_amux_ctl_logic_0/sky130_fd_io__gpiov2_amux_decoder_0/sky130_fd_io__inv_1_12/Y
+ sky130_fd_io__amux_switch_1v2b_1/VDDA sky130_fd_io__res75only_small_8/ROUT sky130_fd_io__gpiov2_amux_ctl_logic_0/sky130_fd_io__gpiov2_amux_decoder_0/sky130_fd_io__inv_1_5/A
+ sky130_fd_io__res75only_small_9/PAD sky130_fd_io__amux_switch_1v2b_1/NG_PAD_VPMP_H
+ sky130_fd_io__gpiov2_amux_ctl_logic_0/sky130_fd_io__gpiov2_amux_decoder_0/sky130_fd_io__nand2_1_1/Y
+ sky130_fd_io__res75only_small_13/ROUT sky130_fd_io__res75only_small_5/ROUT sky130_fd_io__gpiov2_amux_ctl_logic_0/sky130_fd_io__gpiov2_amux_decoder_0/sky130_fd_io__inv_1_14/Y
+ sky130_fd_io__amux_switch_1v2b_1/NG_AMX_VPMP_H sky130_fd_io__res75only_small_1/PAD
+ sky130_fd_io__res75only_small_8/PAD sky130_fd_io__gpiov2_amux_ctl_logic_0/sky130_fd_io__gpiov2_amux_decoder_0/sky130_fd_io__inv_1_7/A
+ sky130_fd_io__gpiov2_amux_ctl_logic_0/sky130_fd_io__gpiov2_amux_decoder_0/sky130_fd_io__inv_1_11/A
+ sky130_fd_io__res75only_small_10/ROUT sky130_fd_io__gpiov2_amux_ctl_logic_0/sky130_fd_io__gpiov2_amux_decoder_0/sky130_fd_io__nand2_1_3/Y
+ sky130_fd_io__gpiov2_amux_ctl_logic_0/sky130_fd_io__gpiov2_amux_decoder_0/sky130_fd_io__nand2_1_0/B
+ sky130_fd_io__gpiov2_amux_ctl_logic_0/sky130_fd_io__gpiov2_amux_decoder_0/sky130_fd_io__inv_1_1/Y
+ sky130_fd_io__gpiov2_amux_ctl_logic_0/sky130_fd_io__gpiov2_amux_decoder_0/sky130_fd_io__inv_1_9/A
+ sky130_fd_io__gpiov2_amux_ctl_logic_0/sky130_fd_io__gpiov2_amux_decoder_0/sky130_fd_io__nand2_1_0/A
+ sky130_fd_io__gpiov2_amux_ctl_logic_0/sky130_fd_io__gpiov2_amux_decoder_0/sky130_fd_io__inv_1_13/A
+ sky130_fd_io__gpiov2_amux_ctl_logic_0/sky130_fd_io__gpiov2_amux_decoder_0/sky130_fd_io__nor2_1_0/Y
+ sky130_fd_io__gpiov2_amux_ctl_logic_0/sky130_fd_io__gpiov2_amux_ls_0/sky130_fd_io__tap_1_0/VPWR
+ sky130_fd_io__gpiov2_amux_ctl_logic_0/sky130_fd_io__gpiov2_amux_decoder_0/sky130_fd_io__nand2_1_2/B
+ sky130_fd_io__res75only_small_0/PAD sky130_fd_io__gpiov2_amux_ctl_logic_0/sky130_fd_io__gpiov2_amux_decoder_0/sky130_fd_io__inv_1_3/Y
+ sky130_fd_io__gpiov2_amux_ctl_logic_0/sky130_fd_io__gpiov2_amux_decoder_0/sky130_fd_io__nand2_1_2/A
+ sky130_fd_io__gpiov2_amux_ctl_logic_0/sky130_fd_io__gpiov2_amux_decoder_0/sky130_fd_io__inv_1_0/A
+ sky130_fd_io__amux_switch_1v2b_0/PG_PAD_VDDIOQ_H_N sky130_fd_io__gpiov2_amux_ctl_logic_0/sky130_fd_io__gpiov2_amux_decoder_0/sky130_fd_io__tap_1_1/VGND
+ sky130_fd_io__res75only_small_9/ROUT w_8674_6609# sky130_fd_io__gpiov2_amux_ctl_logic_0/sky130_fd_io__gpiov2_amux_decoder_0/sky130_fd_io__nor2_1_2/Y
+ sky130_fd_io__amux_switch_1v2b_0/AMUXBUS_HV sky130_fd_io__gpiov2_amux_ctl_logic_0/sky130_fd_io__gpiov2_amux_decoder_0/sky130_fd_io__inv_1_5/Y
+ sky130_fd_io__gpiov2_amux_ctl_logic_0/sky130_fd_io__gpiov2_amux_ls_0/sky130_fd_io__tap_1_0/VPB
+ sky130_fd_io__gpiov2_amux_ctl_logic_0/sky130_fd_io__gpiov2_amux_decoder_0/sky130_fd_io__inv_1_2/A
+ sky130_fd_io__amux_switch_1v2b_0/PAD_HV_N3 sky130_fd_io__res75only_small_6/ROUT
+ sky130_fd_io__res75only_small_7/PAD sky130_fd_io__amux_switch_1v2b_1/AMUXBUS_HV
+ sky130_fd_io__gpiov2_amux_ctl_logic_0/sky130_fd_io__gpiov2_amux_decoder_0/sky130_fd_io__nor2_1_1/B
+ sky130_fd_io__amux_switch_1v2b_0/PAD_HV_N2 sky130_fd_io__gpiov2_amux_ctl_logic_0/sky130_fd_io__gpiov2_amux_decoder_0/sky130_fd_io__inv_1_7/Y
+ sky130_fd_io__amux_switch_1v2b_0/PAD_HV_N1 sky130_fd_io__gpiov2_amux_ctl_logic_0/sky130_fd_io__gpiov2_amux_decoder_0/sky130_fd_io__nor2_1_1/A
+ w_11765_6609# sky130_fd_io__gpiov2_amux_ctl_logic_0/sky130_fd_io__gpiov2_amux_decoder_0/sky130_fd_io__tap_1_2/VPWR
+ sky130_fd_io__gpiov2_amux_ctl_logic_0/sky130_fd_io__gpiov2_amux_decoder_0/sky130_fd_io__inv_1_11/Y
+ w_8674_4393# w_11765_4495# sky130_fd_io__res75only_small_3/ROUT sky130_fd_io__gpiov2_amux_ctl_logic_0/sky130_fd_io__gpiov2_amux_ls_0/sky130_fd_io__tap_1_0/VGND
+ sky130_fd_io__gpiov2_amux_ctl_logic_0/sky130_fd_io__gpiov2_amux_decoder_0/sky130_fd_io__tap_1_2/VGND
+ sky130_fd_io__amux_switch_1v2b_0/PAD_HV_N0 sky130_fd_io__gpiov2_amux_ctl_logic_0/sky130_fd_io__gpiov2_amux_decoder_0/sky130_fd_io__inv_1_4/A
+ sky130_fd_io__amux_switch_1v2b_0/VDDIO sky130_fd_io__res75only_small_5/PAD sky130_fd_io__amux_switch_1v2b_0/PAD_HV_P1
+ sky130_fd_io__gpiov2_amux_ctl_logic_0/sky130_fd_io__gpiov2_amux_decoder_0/sky130_fd_io__tap_1_2/VPB
+ sky130_fd_io__gpiov2_amux_ctl_logic_0/sky130_fd_io__gpiov2_amux_decoder_0/sky130_fd_io__nor2_1_3/B
+ sky130_fd_io__gpiov2_amux_ctl_logic_0/sky130_fd_io__gpiov2_amux_decoder_0/sky130_fd_io__inv_1_8/VGND
+ sky130_fd_io__amux_switch_1v2b_1/VDDIO VSUBS
Xsky130_fd_io__amux_switch_1v2b_0 VSUBS sky130_fd_io__amux_switch_1v2b_1/VDDA sky130_fd_io__amux_switch_1v2b_0/PAD_HV_N2
+ sky130_fd_io__amux_switch_1v2b_0/VDDIO sky130_fd_io__amux_switch_1v2b_0/PAD_HV_N3
+ sky130_fd_io__amux_switch_1v2b_0/AMUXBUS_HV sky130_fd_io__amux_switch_1v2b_0/PG_AMX_VDDA_H_N
+ sky130_fd_io__amux_switch_1v2b_0/NG_AMX_VPMP_H sky130_fd_io__amux_switch_1v2b_0/NG_PAD_VPMP_H
+ sky130_fd_io__amux_switch_1v2b_0/PAD_HV_P0 sky130_fd_io__amux_switch_1v2b_0/PAD_HV_P1
+ sky130_fd_io__amux_switch_1v2b_0/PG_PAD_VDDIOQ_H_N sky130_fd_io__amux_switch_1v2b_0/PAD_HV_N0
+ sky130_fd_io__amux_switch_1v2b_0/PAD_HV_N1 w_11765_6609# w_8674_6609# sky130_fd_io__amux_switch_1v2b
Xsky130_fd_io__amux_switch_1v2b_1 VSUBS sky130_fd_io__amux_switch_1v2b_1/VDDA sky130_fd_io__amux_switch_1v2b_1/PAD_HV_N2
+ sky130_fd_io__amux_switch_1v2b_1/VDDIO sky130_fd_io__amux_switch_1v2b_1/PAD_HV_N3
+ sky130_fd_io__amux_switch_1v2b_1/AMUXBUS_HV sky130_fd_io__amux_switch_1v2b_1/PG_AMX_VDDA_H_N
+ sky130_fd_io__amux_switch_1v2b_1/NG_AMX_VPMP_H sky130_fd_io__amux_switch_1v2b_1/NG_PAD_VPMP_H
+ sky130_fd_io__amux_switch_1v2b_1/PAD_HV_P0 sky130_fd_io__amux_switch_1v2b_1/PAD_HV_P1
+ sky130_fd_io__amux_switch_1v2b_1/PG_PAD_VDDIOQ_H_N sky130_fd_io__amux_switch_1v2b_1/PAD_HV_N0
+ sky130_fd_io__amux_switch_1v2b_1/PAD_HV_N1 w_11765_4495# w_8674_4393# sky130_fd_io__amux_switch_1v2b
Xsky130_fd_io__res75only_small_10 sky130_fd_io__res75only_small_10/PAD sky130_fd_io__res75only_small_10/ROUT
+ sky130_fd_io__res75only_small
Xsky130_fd_io__res75only_small_11 sky130_fd_io__res75only_small_2/PAD sky130_fd_io__res75only_small_10/PAD
+ sky130_fd_io__res75only_small
Xsky130_fd_io__res75only_small_13 sky130_fd_io__res75only_small_13/PAD sky130_fd_io__res75only_small_13/ROUT
+ sky130_fd_io__res75only_small
Xsky130_fd_io__res75only_small_12 sky130_fd_io__res75only_small_1/PAD sky130_fd_io__res75only_small_13/PAD
+ sky130_fd_io__res75only_small
Xsky130_fd_io__res75only_small_0 sky130_fd_io__res75only_small_0/PAD sky130_fd_io__res75only_small_0/ROUT
+ sky130_fd_io__res75only_small
Xsky130_fd_io__res75only_small_1 sky130_fd_io__res75only_small_1/PAD sky130_fd_io__res75only_small_3/PAD
+ sky130_fd_io__res75only_small
Xsky130_fd_io__res75only_small_2 sky130_fd_io__res75only_small_2/PAD sky130_fd_io__res75only_small_0/PAD
+ sky130_fd_io__res75only_small
Xsky130_fd_io__res75only_small_3 sky130_fd_io__res75only_small_3/PAD sky130_fd_io__res75only_small_3/ROUT
+ sky130_fd_io__res75only_small
Xsky130_fd_io__res75only_small_4 sky130_fd_io__res75only_small_5/PAD sky130_fd_io__res75only_small_4/ROUT
+ sky130_fd_io__res75only_small
Xsky130_fd_io__gpiov2_amux_ctl_logic_0 sky130_fd_io__gpiov2_amux_ctl_logic_0/sky130_fd_io__gpiov2_amux_decoder_0/sky130_fd_io__inv_1_4/A
+ sky130_fd_io__gpiov2_amux_ctl_logic_0/sky130_fd_io__gpiov2_amux_decoder_0/sky130_fd_io__inv_1_9/Y
+ sky130_fd_io__gpiov2_amux_ctl_logic_0/sky130_fd_io__gpiov2_amux_decoder_0/sky130_fd_io__nor2_1_2/Y
+ sky130_fd_io__gpiov2_amux_ctl_logic_0/sky130_fd_io__gpiov2_amux_decoder_0/sky130_fd_io__inv_1_6/A
+ sky130_fd_io__gpiov2_amux_ctl_logic_0/sky130_fd_io__gpiov2_amux_decoder_0/sky130_fd_io__nand2_1_1/Y
+ sky130_fd_io__gpiov2_amux_ctl_logic_0/sky130_fd_io__gpiov2_amux_decoder_0/sky130_fd_io__nor2_1_1/B
+ sky130_fd_io__gpiov2_amux_ctl_logic_0/sky130_fd_io__gpiov2_amux_decoder_0/sky130_fd_io__inv_1_0/Y
+ sky130_fd_io__gpiov2_amux_ctl_logic_0/sky130_fd_io__gpiov2_amux_decoder_0/sky130_fd_io__inv_1_8/A
+ sky130_fd_io__gpiov2_amux_ctl_logic_0/sky130_fd_io__gpiov2_amux_decoder_0/sky130_fd_io__nor2_1_1/A
+ sky130_fd_io__gpiov2_amux_ctl_logic_0/sky130_fd_io__gpiov2_amux_decoder_0/sky130_fd_io__nand2_1_3/Y
+ sky130_fd_io__gpiov2_amux_ctl_logic_0/sky130_fd_io__gpiov2_amux_decoder_0/sky130_fd_io__inv_1_11/Y
+ sky130_fd_io__gpiov2_amux_ctl_logic_0/sky130_fd_io__gpiov2_amux_decoder_0/sky130_fd_io__nand2_1_0/B
+ sky130_fd_io__gpiov2_amux_ctl_logic_0/sky130_fd_io__gpiov2_amux_decoder_0/sky130_fd_io__nor2_1_3/B
+ sky130_fd_io__gpiov2_amux_ctl_logic_0/sky130_fd_io__gpiov2_amux_decoder_0/sky130_fd_io__nand2_1_0/A
+ sky130_fd_io__gpiov2_amux_ctl_logic_0/sky130_fd_io__gpiov2_amux_decoder_0/sky130_fd_io__inv_1_2/Y
+ sky130_fd_io__gpiov2_amux_ctl_logic_0/sky130_fd_io__gpiov2_amux_decoder_0/sky130_fd_io__nor2_1_3/A
+ sky130_fd_io__gpiov2_amux_ctl_logic_0/sky130_fd_io__gpiov2_amux_decoder_0/sky130_fd_io__inv_1_13/Y
+ sky130_fd_io__gpiov2_amux_ctl_logic_0/sky130_fd_io__gpiov2_amux_decoder_0/sky130_fd_io__nand2_1_2/B
+ sky130_fd_io__gpiov2_amux_ctl_logic_0/sky130_fd_io__gpiov2_amux_decoder_0/sky130_fd_io__inv_1_10/A
+ sky130_fd_io__gpiov2_amux_ctl_logic_0/sky130_fd_io__gpiov2_amux_decoder_0/sky130_fd_io__inv_1_4/Y
+ sky130_fd_io__gpiov2_amux_ctl_logic_0/sky130_fd_io__gpiov2_amux_decoder_0/sky130_fd_io__nand2_1_2/A
+ sky130_fd_io__gpiov2_amux_ctl_logic_0/sky130_fd_io__gpiov2_amux_decoder_0/sky130_fd_io__inv_1_1/A
+ sky130_fd_io__gpiov2_amux_ctl_logic_0/sky130_fd_io__gpiov2_amux_decoder_0/sky130_fd_io__inv_1_12/A
+ sky130_fd_io__gpiov2_amux_ctl_logic_0/sky130_fd_io__gpiov2_amux_decoder_0/sky130_fd_io__inv_1_6/Y
+ sky130_fd_io__gpiov2_amux_ctl_logic_0/sky130_fd_io__gpiov2_amux_decoder_0/sky130_fd_io__inv_1_3/A
+ sky130_fd_io__gpiov2_amux_ctl_logic_0/sky130_fd_io__gpiov2_amux_decoder_0/sky130_fd_io__inv_1_14/A
+ sky130_fd_io__gpiov2_amux_ctl_logic_0/sky130_fd_io__gpiov2_amux_decoder_0/sky130_fd_io__inv_1_8/Y
+ sky130_fd_io__gpiov2_amux_ctl_logic_0/sky130_fd_io__gpiov2_amux_decoder_0/sky130_fd_io__nor2_1_1/Y
+ sky130_fd_io__gpiov2_amux_ctl_logic_0/sky130_fd_io__gpiov2_amux_decoder_0/sky130_fd_io__inv_1_5/A
+ sky130_fd_io__gpiov2_amux_ctl_logic_0/sky130_fd_io__gpiov2_amux_decoder_0/sky130_fd_io__nand2_1_0/Y
+ sky130_fd_io__gpiov2_amux_ctl_logic_0/sky130_fd_io__gpiov2_amux_decoder_0/sky130_fd_io__nor2_1_0/B
+ sky130_fd_io__gpiov2_amux_ctl_logic_0/sky130_fd_io__gpiov2_amux_decoder_0/sky130_fd_io__nor2_1_3/Y
+ sky130_fd_io__gpiov2_amux_ctl_logic_0/sky130_fd_io__gpiov2_amux_ls_0/sky130_fd_io__tap_1_0/VPWR
+ sky130_fd_io__gpiov2_amux_ctl_logic_0/sky130_fd_io__gpiov2_amux_decoder_0/sky130_fd_io__inv_1_10/Y
+ sky130_fd_io__gpiov2_amux_ctl_logic_0/sky130_fd_io__gpiov2_amux_decoder_0/sky130_fd_io__inv_1_7/A
+ sky130_fd_io__gpiov2_amux_ctl_logic_0/sky130_fd_io__gpiov2_amux_decoder_0/sky130_fd_io__nor2_1_0/A
+ sky130_fd_io__gpiov2_amux_ctl_logic_0/sky130_fd_io__gpiov2_amux_decoder_0/sky130_fd_io__nand2_1_2/Y
+ sky130_fd_io__gpiov2_amux_ctl_logic_0/sky130_fd_io__gpiov2_amux_decoder_0/sky130_fd_io__inv_1_1/Y
+ sky130_fd_io__gpiov2_amux_ctl_logic_0/sky130_fd_io__gpiov2_amux_decoder_0/sky130_fd_io__nor2_1_2/B
+ sky130_fd_io__gpiov2_amux_ctl_logic_0/sky130_fd_io__gpiov2_amux_decoder_0/sky130_fd_io__inv_1_9/A
+ sky130_fd_io__gpiov2_amux_ctl_logic_0/sky130_fd_io__gpiov2_amux_decoder_0/sky130_fd_io__nor2_1_2/A
+ sky130_fd_io__gpiov2_amux_ctl_logic_0/sky130_fd_io__gpiov2_amux_decoder_0/sky130_fd_io__inv_1_12/Y
+ sky130_fd_io__gpiov2_amux_ctl_logic_0/sky130_fd_io__gpiov2_amux_decoder_0/sky130_fd_io__nand2_1_1/B
+ sky130_fd_io__gpiov2_amux_ctl_logic_0/sky130_fd_io__gpiov2_amux_decoder_0/sky130_fd_io__nand2_1_1/A
+ sky130_fd_io__gpiov2_amux_ctl_logic_0/sky130_fd_io__gpiov2_amux_decoder_0/sky130_fd_io__inv_1_3/Y
+ sky130_fd_io__gpiov2_amux_ctl_logic_0/sky130_fd_io__gpiov2_amux_decoder_0/sky130_fd_io__inv_1_14/Y
+ sky130_fd_io__gpiov2_amux_ctl_logic_0/sky130_fd_io__gpiov2_amux_decoder_0/sky130_fd_io__inv_1_0/A
+ sky130_fd_io__gpiov2_amux_ctl_logic_0/sky130_fd_io__gpiov2_amux_decoder_0/sky130_fd_io__tap_1_2/VPB
+ sky130_fd_io__gpiov2_amux_ctl_logic_0/sky130_fd_io__gpiov2_amux_decoder_0/sky130_fd_io__inv_1_11/A
+ sky130_fd_io__gpiov2_amux_ctl_logic_0/sky130_fd_io__gpiov2_amux_decoder_0/sky130_fd_io__nand2_1_3/B
+ sky130_fd_io__gpiov2_amux_ctl_logic_0/sky130_fd_io__gpiov2_amux_decoder_0/sky130_fd_io__inv_1_5/Y
+ sky130_fd_io__gpiov2_amux_ctl_logic_0/sky130_fd_io__gpiov2_amux_ls_0/sky130_fd_io__tap_1_0/VPB
+ sky130_fd_io__gpiov2_amux_ctl_logic_0/sky130_fd_io__gpiov2_amux_ls_0/sky130_fd_io__tap_1_0/VGND
+ sky130_fd_io__gpiov2_amux_ctl_logic_0/sky130_fd_io__gpiov2_amux_decoder_0/sky130_fd_io__tap_1_1/VGND
+ sky130_fd_io__gpiov2_amux_ctl_logic_0/sky130_fd_io__gpiov2_amux_decoder_0/sky130_fd_io__inv_1_8/VGND
+ sky130_fd_io__gpiov2_amux_ctl_logic_0/sky130_fd_io__gpiov2_amux_decoder_0/sky130_fd_io__nand2_1_3/A
+ sky130_fd_io__gpiov2_amux_ctl_logic_0/sky130_fd_io__gpiov2_amux_decoder_0/sky130_fd_io__tap_1_2/VPWR
+ sky130_fd_io__gpiov2_amux_ctl_logic_0/sky130_fd_io__gpiov2_amux_decoder_0/sky130_fd_io__inv_1_2/A
+ VSUBS sky130_fd_io__gpiov2_amux_ctl_logic_0/sky130_fd_io__gpiov2_amux_decoder_0/sky130_fd_io__inv_1_13/A
+ sky130_fd_io__gpiov2_amux_ctl_logic_0/sky130_fd_io__gpiov2_amux_decoder_0/sky130_fd_io__inv_1_7/Y
+ sky130_fd_io__gpiov2_amux_ctl_logic_0/sky130_fd_io__gpiov2_amux_decoder_0/sky130_fd_io__nor2_1_0/Y
+ sky130_fd_io__gpiov2_amux_ctl_logic_0/sky130_fd_io__gpiov2_amux_decoder_0/sky130_fd_io__tap_1_2/VGND
+ sky130_fd_io__gpiov2_amux_ctl_logic
Xsky130_fd_io__res75only_small_5 sky130_fd_io__res75only_small_5/PAD sky130_fd_io__res75only_small_5/ROUT
+ sky130_fd_io__res75only_small
Xsky130_fd_io__res75only_small_6 sky130_fd_io__res75only_small_8/PAD sky130_fd_io__res75only_small_6/ROUT
+ sky130_fd_io__res75only_small
Xsky130_fd_io__res75only_small_7 sky130_fd_io__res75only_small_7/PAD sky130_fd_io__res75only_small_7/ROUT
+ sky130_fd_io__res75only_small
Xsky130_fd_io__res75only_small_8 sky130_fd_io__res75only_small_8/PAD sky130_fd_io__res75only_small_8/ROUT
+ sky130_fd_io__res75only_small
Xsky130_fd_io__res75only_small_9 sky130_fd_io__res75only_small_9/PAD sky130_fd_io__res75only_small_9/ROUT
+ sky130_fd_io__res75only_small
.ends

.subckt sky130_fd_io__gpiov2_ipath_hvls MODE_NORMAL_N IN_VCCHIB INB_VCCHIB IN_VDDIO
+ MODE_VCCHIB_N MODE_NORMAL MODE_VCCHIB VDDIO_Q VSSD OUT OUT_B
X0 VSSD OUT_B OUT VSSD sky130_fd_pr__nfet_g5v0d10v5 ad=0.7 pd=5.28 as=1.325 ps=10.53 w=5 l=0.5
X1 a_1752_1955# a_1175_2172# OUT_B VSSD sky130_fd_pr__nfet_g5v0d10v5 ad=0.42 pd=3.28 as=0.795 ps=6.53 w=3 l=0.5
X2 a_602_2876# IN_VCCHIB a_1930_201# VSSD sky130_fd_pr__nfet_g5v0d10v5 ad=1.325 pd=10.53 as=0.7 ps=5.28 w=5 l=0.5
X3 VDDIO_Q OUT_B OUT VDDIO_Q sky130_fd_pr__pfet_g5v0d10v5 ad=1.325 pd=10.53 as=0.7 ps=5.28 w=5 l=0.5
X4 a_1930_201# MODE_VCCHIB VSSD VSSD sky130_fd_pr__nfet_g5v0d10v5 ad=0.7 pd=5.28 as=0.7 ps=5.28 w=5 l=0.5
X5 VDDIO_Q OUT_B OUT VDDIO_Q sky130_fd_pr__pfet_g5v0d10v5 ad=0.7 pd=5.28 as=1.325 ps=10.53 w=5 l=0.5
X6 a_621_2778# MODE_VCCHIB_N VSSD VSSD sky130_fd_pr__nfet_g5v0d10v5 ad=0.7 pd=5.28 as=1.325 ps=10.53 w=5 l=0.5
X7 a_2024_2876# MODE_NORMAL_N VDDIO_Q VDDIO_Q sky130_fd_pr__pfet_g5v0d10v5 ad=0.7 pd=5.28 as=0.7 ps=5.28 w=5 l=0.5
X8 OUT OUT_B VSSD VSSD sky130_fd_pr__nfet_g5v0d10v5 ad=0.7 pd=5.28 as=0.7 ps=5.28 w=5 l=0.5
X9 VDDIO_Q MODE_VCCHIB_N a_1290_2876# VDDIO_Q sky130_fd_pr__pfet_g5v0d10v5 ad=0.7 pd=5.28 as=0.7 ps=5.28 w=5 l=0.5
X10 a_1930_201# IN_VCCHIB a_602_2876# VSSD sky130_fd_pr__nfet_g5v0d10v5 ad=0.7 pd=5.28 as=0.7 ps=5.28 w=5 l=0.5
X11 a_621_2778# INB_VCCHIB a_881_201# VSSD sky130_fd_pr__nfet_g5v0d10v5 ad=0.7 pd=5.28 as=0.7 ps=5.28 w=5 l=0.5
X12 a_881_201# MODE_VCCHIB VSSD VSSD sky130_fd_pr__nfet_g5v0d10v5 ad=0.7 pd=5.28 as=0.7 ps=5.28 w=5 l=0.5
X13 OUT OUT_B VDDIO_Q VDDIO_Q sky130_fd_pr__pfet_g5v0d10v5 ad=0.7 pd=5.28 as=0.7 ps=5.28 w=5 l=0.5
X14 VSSD MODE_VCCHIB a_1752_1955# VSSD sky130_fd_pr__nfet_g5v0d10v5 ad=0.42 pd=3.28 as=0.42 ps=3.28 w=3 l=0.5
X15 VSSD MODE_VCCHIB a_1930_201# VSSD sky130_fd_pr__nfet_g5v0d10v5 ad=0.7 pd=5.28 as=0.7 ps=5.28 w=5 l=0.5
X16 VSSD MODE_VCCHIB a_1930_201# VSSD sky130_fd_pr__nfet_g5v0d10v5 ad=0.7 pd=5.28 as=1.325 ps=10.53 w=5 l=0.5
X17 a_621_2778# a_602_2876# VDDIO_Q VDDIO_Q sky130_fd_pr__pfet_g5v0d10v5 ad=0.3975 pd=3.53 as=0.21 ps=1.78 w=1.5 l=0.5
X18 VSSD OUT_B OUT VSSD sky130_fd_pr__nfet_g5v0d10v5 ad=1.325 pd=10.53 as=0.7 ps=5.28 w=5 l=0.5
X19 a_1290_2876# a_1175_2172# OUT_B VDDIO_Q sky130_fd_pr__pfet_g5v0d10v5 ad=0.7 pd=5.28 as=0.7 ps=5.28 w=5 l=0.5
X20 VDDIO_Q MODE_NORMAL_N a_2024_2876# VDDIO_Q sky130_fd_pr__pfet_g5v0d10v5 ad=0.7 pd=5.28 as=1.325 ps=10.53 w=5 l=0.5
X21 a_1752_2267# MODE_NORMAL VSSD VSSD sky130_fd_pr__nfet_g5v0d10v5 ad=0.42 pd=3.28 as=0.42 ps=3.28 w=3 l=0.5
X22 a_881_201# MODE_VCCHIB VSSD VSSD sky130_fd_pr__nfet_g5v0d10v5 ad=1.325 pd=10.53 as=0.7 ps=5.28 w=5 l=0.5
X23 a_881_201# INB_VCCHIB a_621_2778# VSSD sky130_fd_pr__nfet_g5v0d10v5 ad=0.7 pd=5.28 as=0.7 ps=5.28 w=5 l=0.5
X24 a_1175_2172# a_602_2876# VDDIO_Q VDDIO_Q sky130_fd_pr__pfet_g5v0d10v5 ad=0.3975 pd=3.53 as=0.3975 ps=3.53 w=1.5 l=0.5
X25 VDDIO_Q MODE_NORMAL a_2911_2876# VDDIO_Q sky130_fd_pr__pfet_g5v0d10v5 ad=1.325 pd=10.53 as=0.7 ps=5.28 w=5 l=0.5
X26 VDDIO_Q OUT_B OUT VDDIO_Q sky130_fd_pr__pfet_g5v0d10v5 ad=0.7 pd=5.28 as=0.7 ps=5.28 w=5 l=0.5
X27 VSSD MODE_VCCHIB a_881_201# VSSD sky130_fd_pr__nfet_g5v0d10v5 ad=0.7 pd=5.28 as=0.7 ps=5.28 w=5 l=0.5
X28 VDDIO_Q a_621_2778# a_602_2876# VDDIO_Q sky130_fd_pr__pfet_g5v0d10v5 ad=0.21 pd=1.78 as=0.3975 ps=3.53 w=1.5 l=0.5
X29 a_2024_2876# IN_VDDIO OUT_B VDDIO_Q sky130_fd_pr__pfet_g5v0d10v5 ad=1.325 pd=10.53 as=0.7 ps=5.28 w=5 l=0.5
X30 OUT_B a_1175_2172# a_1290_2876# VDDIO_Q sky130_fd_pr__pfet_g5v0d10v5 ad=0.7 pd=5.28 as=1.325 ps=10.53 w=5 l=0.5
X31 OUT_B IN_VDDIO a_1752_2267# VSSD sky130_fd_pr__nfet_g5v0d10v5 ad=0.795 pd=6.53 as=0.42 ps=3.28 w=3 l=0.5
X32 VSSD MODE_VCCHIB a_881_201# VSSD sky130_fd_pr__nfet_g5v0d10v5 ad=0.7 pd=5.28 as=0.7 ps=5.28 w=5 l=0.5
X33 a_881_201# INB_VCCHIB a_621_2778# VSSD sky130_fd_pr__nfet_g5v0d10v5 ad=0.7 pd=5.28 as=0.7 ps=5.28 w=5 l=0.5
X34 a_602_2876# IN_VCCHIB a_1930_201# VSSD sky130_fd_pr__nfet_g5v0d10v5 ad=0.7 pd=5.28 as=0.7 ps=5.28 w=5 l=0.5
X35 a_2911_2876# MODE_VCCHIB OUT_B VDDIO_Q sky130_fd_pr__pfet_g5v0d10v5 ad=0.7 pd=5.28 as=1.325 ps=10.53 w=5 l=0.5
X36 OUT OUT_B VDDIO_Q VDDIO_Q sky130_fd_pr__pfet_g5v0d10v5 ad=0.7 pd=5.28 as=0.7 ps=5.28 w=5 l=0.5
X37 a_1930_201# MODE_VCCHIB VSSD VSSD sky130_fd_pr__nfet_g5v0d10v5 ad=0.7 pd=5.28 as=0.7 ps=5.28 w=5 l=0.5
X38 a_1175_2172# a_602_2876# VSSD VSSD sky130_fd_pr__nfet_g5v0d10v5 ad=0.3975 pd=3.53 as=0.3975 ps=3.53 w=1.5 l=0.5
X39 a_1290_2876# MODE_VCCHIB_N VDDIO_Q VDDIO_Q sky130_fd_pr__pfet_g5v0d10v5 ad=1.325 pd=10.53 as=0.7 ps=5.28 w=5 l=0.5
X40 OUT_B IN_VDDIO a_2024_2876# VDDIO_Q sky130_fd_pr__pfet_g5v0d10v5 ad=0.7 pd=5.28 as=0.7 ps=5.28 w=5 l=0.5
.ends

.subckt sky130_fd_io__gpiov2_vcchib_in_buf IN_H MODE_VCCHIB_LV_N VCCHIB VSSD OUT OUT_N
X0 VCCHIB MODE_VCCHIB_LV_N a_612_2476# VCCHIB sky130_fd_pr__pfet_01v8 ad=0.7 pd=5.28 as=1.325 ps=10.53 w=5 l=0.25
X1 a_612_2476# MODE_VCCHIB_LV_N VCCHIB VCCHIB sky130_fd_pr__pfet_01v8 ad=0.7 pd=5.28 as=0.7 ps=5.28 w=5 l=0.25
X2 VCCHIB MODE_VCCHIB_LV_N a_612_2476# VCCHIB sky130_fd_pr__pfet_01v8 ad=0.7 pd=5.28 as=0.7 ps=5.28 w=5 l=0.25
X3 a_538_595# a_591_563# a_751_595# VSSD sky130_fd_pr__nfet_g5v0d10v5 ad=0.14 pd=1.28 as=0.14 ps=1.28 w=1 l=0.8
X4 OUT OUT_N VSSD VSSD sky130_fd_pr__nfet_01v8 ad=0.14 pd=1.28 as=0.14 ps=1.28 w=1 l=0.25
X5 a_446_3055# MODE_VCCHIB_LV_N VSSD VSSD sky130_fd_pr__nfet_01v8 ad=0.14 pd=1.28 as=0.14 ps=1.28 w=1 l=0.25
X6 VCCHIB a_446_3055# OUT_N VCCHIB sky130_fd_pr__pfet_01v8 ad=0.7 pd=5.28 as=1.325 ps=10.53 w=5 l=0.25
X7 VSSD a_446_3055# OUT_N VSSD sky130_fd_pr__nfet_01v8 ad=0.14 pd=1.28 as=0.265 ps=2.53 w=1 l=0.25
X8 a_751_595# IN_H VSSD VSSD sky130_fd_pr__nfet_g5v0d10v5 ad=1.325 pd=10.53 as=0.7 ps=5.28 w=5 l=0.8
X9 a_751_595# a_591_563# a_538_595# VSSD sky130_fd_pr__nfet_g5v0d10v5 ad=0.265 pd=2.53 as=0.14 ps=1.28 w=1 l=0.8
X10 VSSD OUT_N OUT VSSD sky130_fd_pr__nfet_01v8 ad=0.265 pd=2.53 as=0.14 ps=1.28 w=1 l=0.25
X11 VCCHIB MODE_VCCHIB_LV_N a_612_3332# VCCHIB sky130_fd_pr__pfet_01v8 ad=0.795 pd=6.53 as=0.795 ps=6.53 w=3 l=0.25
X12 VSSD MODE_VCCHIB_LV_N a_446_3055# VSSD sky130_fd_pr__nfet_01v8 ad=0.265 pd=2.53 as=0.14 ps=1.28 w=1 l=0.25
X13 a_446_3055# a_591_563# a_612_3332# VCCHIB sky130_fd_pr__pfet_01v8 ad=0.14 pd=1.28 as=0.265 ps=2.53 w=1 l=0.25
X14 a_612_3332# a_591_563# a_446_3055# VCCHIB sky130_fd_pr__pfet_01v8 ad=0.265 pd=2.53 as=0.14 ps=1.28 w=1 l=0.25
X15 a_446_3055# a_591_563# VSSD VSSD sky130_fd_pr__nfet_01v8 ad=0.14 pd=1.28 as=0.14 ps=1.28 w=1 l=0.25
X16 a_751_595# a_591_563# a_538_595# VSSD sky130_fd_pr__nfet_g5v0d10v5 ad=0.14 pd=1.28 as=0.265 ps=2.53 w=1 l=0.8
X17 VSSD OUT_N OUT VSSD sky130_fd_pr__nfet_01v8 ad=0.14 pd=1.28 as=0.265 ps=2.53 w=1 l=0.25
X18 VSSD IN_H a_751_595# VSSD sky130_fd_pr__nfet_g5v0d10v5 ad=0.7 pd=5.28 as=0.7 ps=5.28 w=5 l=0.8
X19 a_751_595# IN_H a_591_563# VSSD sky130_fd_pr__nfet_g5v0d10v5 ad=0.7 pd=5.28 as=0.7 ps=5.28 w=5 l=0.8
X20 a_591_563# IN_H a_612_2476# VCCHIB sky130_fd_pr__pfet_g5v0d10v5 ad=0.7 pd=5.28 as=1.325 ps=10.53 w=5 l=0.8
X21 a_591_563# IN_H a_751_595# VSSD sky130_fd_pr__nfet_g5v0d10v5 ad=0.7 pd=5.28 as=1.325 ps=10.53 w=5 l=0.8
X22 VSSD VSSD VSSD VSSD sky130_fd_pr__nfet_g5v0d10v5 ad=1.325 pd=10.53 as=0 ps=0 w=5 l=0.8
X23 a_538_595# MODE_VCCHIB_LV_N VCCHIB VCCHIB sky130_fd_pr__pfet_01v8 ad=1.325 pd=10.53 as=0.7 ps=5.28 w=5 l=0.25
X24 a_612_2476# IN_H a_591_563# VCCHIB sky130_fd_pr__pfet_g5v0d10v5 ad=1.325 pd=10.53 as=0.7 ps=5.28 w=5 l=0.8
X25 VSSD a_591_563# a_446_3055# VSSD sky130_fd_pr__nfet_01v8 ad=0.14 pd=1.28 as=0.14 ps=1.28 w=1 l=0.25
X26 OUT OUT_N VCCHIB VCCHIB sky130_fd_pr__pfet_01v8 ad=1.325 pd=10.53 as=0.7 ps=5.28 w=5 l=0.25
X27 VSSD VSSD VSSD VSSD sky130_fd_pr__nfet_g5v0d10v5 ad=0.265 pd=2.53 as=0 ps=0 w=1 l=0.8
.ends

.subckt sky130_fd_io__gpiov2_in_buf MODE_NORMAL_N IN_H IN_VT VTRIP_SEL_H VTRIP_SEL_H_N
+ VDDIO_Q VSSD OUT OUT_N m1_n467_n748#
X0 a_249_n802# IN_H VSSD VSSD sky130_fd_pr__nfet_g5v0d10v5 ad=0.7 pd=5.28 as=0.7 ps=5.28 w=5 l=0.8
X1 a_2073_1865# a_36_n802# a_249_n802# VSSD sky130_fd_pr__nfet_g5v0d10v5 ad=0.14 pd=1.28 as=0.14 ps=1.28 w=1 l=0.8
X2 VSSD a_36_n802# a_2651_1865# VSSD sky130_fd_pr__nfet_g5v0d10v5 ad=0.795 pd=6.53 as=0.42 ps=3.28 w=3 l=0.5
X3 VDDIO_Q VDDIO_Q VDDIO_Q VDDIO_Q sky130_fd_pr__pfet_g5v0d10v5 ad=1.325 pd=10.53 as=0 ps=0 w=5 l=0.8
X4 a_249_n802# IN_H VSSD VSSD sky130_fd_pr__nfet_g5v0d10v5 ad=0.7 pd=5.28 as=0.7 ps=5.28 w=5 l=0.8
X5 VDDIO_Q MODE_NORMAL_N a_219_1865# VDDIO_Q sky130_fd_pr__pfet_g5v0d10v5 ad=1.325 pd=10.53 as=0.7 ps=5.28 w=5 l=0.5
X6 a_219_1865# MODE_NORMAL_N VDDIO_Q VDDIO_Q sky130_fd_pr__pfet_g5v0d10v5 ad=0.7 pd=5.28 as=1.325 ps=10.53 w=5 l=0.5
X7 a_249_n802# IN_H a_36_n802# VSSD sky130_fd_pr__nfet_g5v0d10v5 ad=0.7 pd=5.28 as=0.7 ps=5.28 w=5 l=0.8
X8 a_3531_2403# MODE_NORMAL_N a_3358_2403# VDDIO_Q sky130_fd_pr__pfet_g5v0d10v5 ad=0.14 pd=1.28 as=0.265 ps=2.53 w=1 l=0.6
X9 a_36_n802# IN_H a_249_n802# VSSD sky130_fd_pr__nfet_g5v0d10v5 ad=0.7 pd=5.28 as=0.7 ps=5.28 w=5 l=0.8
X10 VSSD VSSD VSSD VSSD sky130_fd_pr__nfet_g5v0d10v5 ad=1.325 pd=10.53 as=0 ps=0 w=5 l=0.8
X11 a_3358_2403# MODE_NORMAL_N VSSD VSSD sky130_fd_pr__nfet_g5v0d10v5 ad=0.098 pd=0.98 as=0.196 ps=1.96 w=0.7 l=0.6
X12 a_2385_1865# MODE_NORMAL_N VDDIO_Q VDDIO_Q sky130_fd_pr__pfet_g5v0d10v5 ad=1.325 pd=10.53 as=0.7 ps=5.28 w=5 l=0.5
X13 a_36_n802# IN_H a_219_1865# VDDIO_Q sky130_fd_pr__pfet_g5v0d10v5 ad=0.7 pd=5.28 as=1.325 ps=10.53 w=5 l=0.8
X14 VDDIO_Q MODE_NORMAL_N a_2073_1865# VDDIO_Q sky130_fd_pr__pfet_g5v0d10v5 ad=0.7 pd=5.28 as=0.7 ps=5.28 w=5 l=0.5
X15 VDDIO_Q VTRIP_SEL_H a_3531_2403# VDDIO_Q sky130_fd_pr__pfet_g5v0d10v5 ad=0.14 pd=1.28 as=0.14 ps=1.28 w=1 l=0.6
X16 a_249_n802# a_36_n802# a_2073_1865# VSSD sky130_fd_pr__nfet_g5v0d10v5 ad=0.265 pd=2.53 as=0.14 ps=1.28 w=1 l=0.8
X17 VSSD VTRIP_SEL_H a_3358_2403# VSSD sky130_fd_pr__nfet_g5v0d10v5 ad=0.098 pd=0.98 as=0.098 ps=0.98 w=0.7 l=0.6
X18 VSSD IN_H a_249_n802# VSSD sky130_fd_pr__nfet_g5v0d10v5 ad=0.7 pd=5.28 as=0.7 ps=5.28 w=5 l=0.8
X19 a_917_1865# a_973_1767# VDDIO_Q VDDIO_Q sky130_fd_pr__pfet_g5v0d10v5 ad=1.325 pd=10.53 as=0.7 ps=5.28 w=5 l=0.5
X20 VDDIO_Q a_2651_1865# OUT_N VDDIO_Q sky130_fd_pr__pfet_g5v0d10v5 ad=0.7 pd=5.28 as=1.325 ps=10.53 w=5 l=0.5
X21 OUT OUT_N VDDIO_Q VDDIO_Q sky130_fd_pr__pfet_g5v0d10v5 ad=1.325 pd=10.53 as=0.7 ps=5.28 w=5 l=0.5
X22 VSSD IN_H a_249_n802# VSSD sky130_fd_pr__nfet_g5v0d10v5 ad=0.7 pd=5.28 as=0.7 ps=5.28 w=5 l=0.8
X23 a_973_1767# a_3358_2403# VDDIO_Q VDDIO_Q sky130_fd_pr__pfet_g5v0d10v5 ad=0.265 pd=2.53 as=0.14 ps=1.28 w=1 l=0.6
X24 a_2651_1865# a_36_n802# a_2385_1865# VDDIO_Q sky130_fd_pr__pfet_g5v0d10v5 ad=0.795 pd=6.53 as=0.795 ps=6.53 w=3 l=0.5
X25 VDDIO_Q a_973_1767# a_1761_1865# VDDIO_Q sky130_fd_pr__pfet_g5v0d10v5 ad=0.7 pd=5.28 as=0.7 ps=5.28 w=5 l=0.5
X26 a_2073_1865# MODE_NORMAL_N VDDIO_Q VDDIO_Q sky130_fd_pr__pfet_g5v0d10v5 ad=0.7 pd=5.28 as=0.7 ps=5.28 w=5 l=0.5
X27 a_973_1767# a_3358_2403# VSSD VSSD sky130_fd_pr__nfet_g5v0d10v5 ad=0.1855 pd=1.93 as=0.098 ps=0.98 w=0.7 l=0.6
X28 a_249_n802# IN_H a_36_n802# VSSD sky130_fd_pr__nfet_g5v0d10v5 ad=0.7 pd=5.28 as=0.7 ps=5.28 w=5 l=0.8
X29 a_2651_1865# MODE_NORMAL_N VSSD VSSD sky130_fd_pr__nfet_g5v0d10v5 ad=0.42 pd=3.28 as=0.42 ps=3.28 w=3 l=0.5
X30 a_249_n802# IN_H a_36_n802# VSSD sky130_fd_pr__nfet_g5v0d10v5 ad=0.7 pd=5.28 as=1.325 ps=10.53 w=5 l=0.8
X31 a_36_n802# IN_H a_249_n802# VSSD sky130_fd_pr__nfet_g5v0d10v5 ad=0.7 pd=5.28 as=0.7 ps=5.28 w=5 l=0.8
X32 a_1761_1865# a_36_n802# a_249_n802# VSSD sky130_fd_pr__nfet_g5v0d10v5 ad=0.7 pd=5.28 as=0.7 ps=5.28 w=5 l=0.8
X33 a_2073_1865# a_36_n802# a_249_n802# VSSD sky130_fd_pr__nfet_g5v0d10v5 ad=0.14 pd=1.28 as=0.265 ps=2.53 w=1 l=0.8
X34 a_249_n802# a_36_n802# a_2073_1865# VSSD sky130_fd_pr__nfet_g5v0d10v5 ad=0.14 pd=1.28 as=0.14 ps=1.28 w=1 l=0.8
X35 a_249_n802# a_36_n802# a_1761_1865# VSSD sky130_fd_pr__nfet_g5v0d10v5 ad=1.325 pd=10.53 as=0.7 ps=5.28 w=5 l=0.8
X36 a_249_n802# IN_H VSSD VSSD sky130_fd_pr__nfet_g5v0d10v5 ad=0.7 pd=5.28 as=0.7 ps=5.28 w=5 l=0.8
X37 a_3531_2403# MODE_NORMAL_N a_3358_2403# VDDIO_Q sky130_fd_pr__pfet_g5v0d10v5 ad=0.14 pd=1.28 as=0.265 ps=2.53 w=1 l=0.6
X38 VSSD IN_VT a_249_n802# VSSD sky130_fd_pr__nfet_g5v0d10v5 ad=0.7 pd=5.28 as=0.7 ps=5.28 w=5 l=0.8
X39 VSSD IN_H a_249_n802# VSSD sky130_fd_pr__nfet_g5v0d10v5 ad=1.325 pd=10.53 as=1.325 ps=10.53 w=5 l=0.8
X40 VSSD VTRIP_SEL_H_N IN_VT VSSD sky130_fd_pr__nfet_g5v0d10v5 ad=0.42 pd=3.28 as=0.795 ps=6.53 w=3 l=1
X41 VDDIO_Q VTRIP_SEL_H a_3531_2403# VDDIO_Q sky130_fd_pr__pfet_g5v0d10v5 ad=0.14 pd=1.28 as=0.14 ps=1.28 w=1 l=0.6
X42 VSSD VSSD VSSD VSSD sky130_fd_pr__nfet_g5v0d10v5 ad=1.325 pd=10.53 as=0 ps=0 w=5 l=0.8
X43 VDDIO_Q a_973_1767# a_917_1865# VDDIO_Q sky130_fd_pr__pfet_g5v0d10v5 ad=0.7 pd=5.28 as=0.7 ps=5.28 w=5 l=0.5
X44 a_249_n802# a_36_n802# a_1761_1865# VSSD sky130_fd_pr__nfet_g5v0d10v5 ad=0.7 pd=5.28 as=0.7 ps=5.28 w=5 l=0.8
X45 a_917_1865# IN_H a_36_n802# VDDIO_Q sky130_fd_pr__pfet_g5v0d10v5 ad=0.7 pd=5.28 as=0.7 ps=5.28 w=5 l=0.8
X46 a_973_1767# a_3358_2403# VDDIO_Q VDDIO_Q sky130_fd_pr__pfet_g5v0d10v5 ad=0.265 pd=2.53 as=0.14 ps=1.28 w=1 l=0.6
X47 a_1761_1865# a_36_n802# a_249_n802# VSSD sky130_fd_pr__nfet_g5v0d10v5 ad=0.7 pd=5.28 as=0.7 ps=5.28 w=5 l=0.8
X48 a_2651_1865# a_36_n802# VSSD VSSD sky130_fd_pr__nfet_g5v0d10v5 ad=0.42 pd=3.28 as=0.42 ps=3.28 w=3 l=0.5
X49 VSSD a_2651_1865# OUT_N VSSD sky130_fd_pr__nfet_g5v0d10v5 ad=0.7 pd=5.28 as=1.325 ps=10.53 w=5 l=0.5
X50 OUT OUT_N VSSD VSSD sky130_fd_pr__nfet_g5v0d10v5 ad=1.325 pd=10.53 as=0.7 ps=5.28 w=5 l=0.5
X51 a_1761_1865# a_973_1767# VDDIO_Q VDDIO_Q sky130_fd_pr__pfet_g5v0d10v5 ad=0.7 pd=5.28 as=0.7 ps=5.28 w=5 l=0.5
X52 VSSD MODE_NORMAL_N a_2651_1865# VSSD sky130_fd_pr__nfet_g5v0d10v5 ad=0.42 pd=3.28 as=0.42 ps=3.28 w=3 l=0.5
.ends

.subckt sky130_fd_io__gpiov2_ipath_lvls IN_VCCHIB IN_VDDIO MODE_NORMAL_LV MODE_NORMAL_LV_N
+ MODE_VCCHIB_LV MODE_VCCHIB_LV_N VCCHIB VSSD OUT OUT_B a_323_2354#
X0 VSSD OUT_B OUT VSSD sky130_fd_pr__nfet_01v8 ad=0.795 pd=6.53 as=0.42 ps=3.28 w=3 l=0.25
X1 VCCHIB MODE_NORMAL_LV_N a_436_2754# VCCHIB sky130_fd_pr__pfet_01v8 ad=0.42 pd=3.28 as=0.42 ps=3.28 w=3 l=0.25
X2 VCCHIB MODE_VCCHIB_LV_N a_1504_2754# VCCHIB sky130_fd_pr__pfet_01v8 ad=0.42 pd=3.28 as=0.795 ps=6.53 w=3 l=0.25
X3 a_823_n317# MODE_NORMAL_LV VSSD VSSD sky130_fd_pr__nfet_01v8 ad=0.795 pd=6.53 as=0.42 ps=3.28 w=3 l=0.25
X4 a_114_2354# IN_VDDIO VCCHIB VCCHIB sky130_fd_pr__pfet_g5v0d10v5 ad=0.7 pd=5.28 as=1.325 ps=10.53 w=5 l=0.5
X5 a_1679_n317# IN_VCCHIB OUT_B VSSD sky130_fd_pr__nfet_01v8 ad=0.42 pd=3.28 as=0.42 ps=3.28 w=3 l=0.25
X6 OUT OUT_B VCCHIB VCCHIB sky130_fd_pr__pfet_01v8 ad=0.42 pd=3.28 as=0.795 ps=6.53 w=3 l=0.25
X7 a_1504_2754# IN_VCCHIB OUT_B VCCHIB sky130_fd_pr__pfet_01v8 ad=0.795 pd=6.53 as=0.42 ps=3.28 w=3 l=0.25
X8 a_323_2354# a_114_2354# VSSD VSSD sky130_fd_pr__nfet_01v8 ad=0.795 pd=6.53 as=0.42 ps=3.28 w=3 l=0.25
X9 a_436_2754# MODE_NORMAL_LV_N VCCHIB VCCHIB sky130_fd_pr__pfet_01v8 ad=0.795 pd=6.53 as=0.42 ps=3.28 w=3 l=0.25
X10 OUT_B a_323_2354# a_436_2754# VCCHIB sky130_fd_pr__pfet_01v8 ad=0.42 pd=3.28 as=0.795 ps=6.53 w=3 l=0.25
X11 VCCHIB OUT_B OUT VCCHIB sky130_fd_pr__pfet_01v8 ad=0.795 pd=6.53 as=0.42 ps=3.28 w=3 l=0.25
X12 VCCHIB MODE_NORMAL_LV a_114_2354# VCCHIB sky130_fd_pr__pfet_01v8 ad=0.7 pd=5.28 as=1.325 ps=10.53 w=5 l=0.25
X13 VCCHIB OUT_B OUT VCCHIB sky130_fd_pr__pfet_01v8 ad=0.42 pd=3.28 as=0.42 ps=3.28 w=3 l=0.25
X14 a_823_n317# a_323_2354# OUT_B VSSD sky130_fd_pr__nfet_01v8 ad=0.42 pd=3.28 as=0.42 ps=3.28 w=3 l=0.25
X15 a_1679_n317# MODE_VCCHIB_LV VSSD VSSD sky130_fd_pr__nfet_01v8 ad=0.795 pd=6.53 as=0.42 ps=3.28 w=3 l=0.25
X16 a_2141_2754# MODE_NORMAL_LV OUT_B VCCHIB sky130_fd_pr__pfet_01v8 ad=0.42 pd=3.28 as=0.795 ps=6.53 w=3 l=0.25
X17 a_1504_2754# MODE_VCCHIB_LV_N VCCHIB VCCHIB sky130_fd_pr__pfet_01v8 ad=0.42 pd=3.28 as=0.42 ps=3.28 w=3 l=0.25
X18 VSSD MODE_NORMAL_LV a_823_n317# VSSD sky130_fd_pr__nfet_01v8 ad=0.42 pd=3.28 as=0.42 ps=3.28 w=3 l=0.25
X19 a_316_n17# IN_VDDIO a_114_2354# VSSD sky130_fd_pr__nfet_g5v0d10v5 ad=0.3975 pd=3.53 as=0.3975 ps=3.53 w=1.5 l=0.5
X20 VSSD MODE_VCCHIB_LV a_1679_n317# VSSD sky130_fd_pr__nfet_01v8 ad=0.42 pd=3.28 as=0.42 ps=3.28 w=3 l=0.25
X21 VCCHIB MODE_VCCHIB_LV a_2141_2754# VCCHIB sky130_fd_pr__pfet_01v8 ad=0.795 pd=6.53 as=0.42 ps=3.28 w=3 l=0.25
X22 VCCHIB IN_VDDIO a_114_2354# VCCHIB sky130_fd_pr__pfet_g5v0d10v5 ad=1.325 pd=10.53 as=0.7 ps=5.28 w=5 l=0.5
X23 OUT_B IN_VCCHIB a_1504_2754# VCCHIB sky130_fd_pr__pfet_01v8 ad=0.42 pd=3.28 as=0.42 ps=3.28 w=3 l=0.25
X24 VSSD MODE_NORMAL_LV a_316_n17# VSSD sky130_fd_pr__nfet_01v8 ad=0.42 pd=3.28 as=0.795 ps=6.53 w=3 l=0.25
X25 OUT OUT_B VSSD VSSD sky130_fd_pr__nfet_01v8 ad=0.42 pd=3.28 as=0.795 ps=6.53 w=3 l=0.25
X26 a_436_2754# a_323_2354# OUT_B VCCHIB sky130_fd_pr__pfet_01v8 ad=0.42 pd=3.28 as=0.42 ps=3.28 w=3 l=0.25
X27 a_323_2354# a_114_2354# VCCHIB VCCHIB sky130_fd_pr__pfet_01v8 ad=1.325 pd=10.53 as=0.7 ps=5.28 w=5 l=0.25
X28 OUT OUT_B VCCHIB VCCHIB sky130_fd_pr__pfet_01v8 ad=0.42 pd=3.28 as=0.42 ps=3.28 w=3 l=0.25
X29 OUT_B a_323_2354# a_823_n317# VSSD sky130_fd_pr__nfet_01v8 ad=0.42 pd=3.28 as=0.795 ps=6.53 w=3 l=0.25
X30 OUT_B IN_VCCHIB a_1679_n317# VSSD sky130_fd_pr__nfet_01v8 ad=0.42 pd=3.28 as=0.795 ps=6.53 w=3 l=0.25
.ends

.subckt sky130_fd_io__gpiov2_inbuf_lvinv_x1 IN VGND VPWR OUT
X0 VPWR IN OUT VPWR sky130_fd_pr__pfet_01v8_hvt ad=0.795 pd=6.53 as=0.795 ps=6.53 w=3 l=0.25
X1 VGND IN OUT VGND sky130_fd_pr__nfet_01v8 ad=0.265 pd=2.53 as=0.265 ps=2.53 w=1 l=0.25
.ends

.subckt sky130_fd_io__gpiov2_ibuf_se VTRIP_SEL_H_N VCCHIB ENABLE_VDDIO_LV MODE_NORMAL_N
+ IBUFMUX_OUT IN_VT IN_H VTRIP_SEL_H MODE_VCCHIB_N IBUFMUX_OUT_H sky130_fd_io__gpiov2_in_buf_0/m1_n467_n748#
+ VDDIO_Q VSSD sky130_fd_io__gpiov2_ipath_lvls_0/a_323_2354#
Xsky130_fd_io__gpiov2_ipath_hvls_0 MODE_NORMAL_N sky130_fd_io__gpiov2_vcchib_in_buf_0/OUT
+ sky130_fd_io__gpiov2_vcchib_in_buf_0/OUT_N sky130_fd_io__gpiov2_in_buf_0/OUT MODE_VCCHIB_N
+ sky130_fd_io__gpiov2_ipath_hvls_0/MODE_NORMAL sky130_fd_io__gpiov2_ipath_hvls_0/MODE_VCCHIB
+ VDDIO_Q VSSD IBUFMUX_OUT_H sky130_fd_io__gpiov2_ipath_hvls_0/OUT_B sky130_fd_io__gpiov2_ipath_hvls
Xsky130_fd_io__gpiov2_vcchib_in_buf_0 IN_H sky130_fd_io__gpiov2_inbuf_lvinv_x1_1/IN
+ VCCHIB VSSD sky130_fd_io__gpiov2_vcchib_in_buf_0/OUT sky130_fd_io__gpiov2_vcchib_in_buf_0/OUT_N
+ sky130_fd_io__gpiov2_vcchib_in_buf
Xsky130_fd_io__gpiov2_in_buf_0 MODE_NORMAL_N IN_H IN_VT VTRIP_SEL_H VTRIP_SEL_H_N
+ VDDIO_Q VSSD sky130_fd_io__gpiov2_in_buf_0/OUT sky130_fd_io__gpiov2_in_buf_0/OUT_N
+ sky130_fd_io__gpiov2_in_buf_0/m1_n467_n748# sky130_fd_io__gpiov2_in_buf
Xsky130_fd_io__gpiov2_ipath_lvls_0 sky130_fd_io__gpiov2_vcchib_in_buf_0/OUT sky130_fd_io__gpiov2_in_buf_0/OUT
+ sky130_fd_io__gpiov2_inbuf_lvinv_x1_0/OUT sky130_fd_io__gpiov2_inbuf_lvinv_x1_0/IN
+ sky130_fd_io__gpiov2_inbuf_lvinv_x1_1/OUT sky130_fd_io__gpiov2_inbuf_lvinv_x1_1/IN
+ VCCHIB VSSD IBUFMUX_OUT sky130_fd_io__gpiov2_ipath_lvls_0/OUT_B sky130_fd_io__gpiov2_ipath_lvls_0/a_323_2354#
+ sky130_fd_io__gpiov2_ipath_lvls
Xsky130_fd_io__gpiov2_inbuf_lvinv_x1_0 sky130_fd_io__gpiov2_inbuf_lvinv_x1_0/IN VSSD
+ VCCHIB sky130_fd_io__gpiov2_inbuf_lvinv_x1_0/OUT sky130_fd_io__gpiov2_inbuf_lvinv_x1
Xsky130_fd_io__gpiov2_inbuf_lvinv_x1_1 sky130_fd_io__gpiov2_inbuf_lvinv_x1_1/IN VSSD
+ VCCHIB sky130_fd_io__gpiov2_inbuf_lvinv_x1_1/OUT sky130_fd_io__gpiov2_inbuf_lvinv_x1
X0 VCCHIB ENABLE_VDDIO_LV sky130_fd_io__gpiov2_inbuf_lvinv_x1_1/IN VCCHIB sky130_fd_pr__pfet_g5v0d10v5 ad=0.14 pd=1.28 as=0.14 ps=1.28 w=1 l=0.6
X1 VCCHIB sky130_fd_io__gpiov2_ipath_hvls_0/MODE_NORMAL sky130_fd_io__gpiov2_inbuf_lvinv_x1_0/IN VCCHIB sky130_fd_pr__pfet_g5v0d10v5 ad=0.265 pd=2.53 as=0.14 ps=1.28 w=1 l=0.6
X2 VSSD MODE_NORMAL_N sky130_fd_io__gpiov2_ipath_hvls_0/MODE_NORMAL VSSD sky130_fd_pr__nfet_g5v0d10v5 ad=0.098 pd=0.98 as=0.1855 ps=1.93 w=0.7 l=0.6
X3 sky130_fd_io__gpiov2_inbuf_lvinv_x1_1/IN sky130_fd_io__gpiov2_ipath_hvls_0/MODE_VCCHIB VCCHIB VCCHIB sky130_fd_pr__pfet_g5v0d10v5 ad=0.14 pd=1.28 as=0.265 ps=2.53 w=1 l=0.6
X4 sky130_fd_io__gpiov2_inbuf_lvinv_x1_0/IN ENABLE_VDDIO_LV VCCHIB VCCHIB sky130_fd_pr__pfet_g5v0d10v5 ad=0.14 pd=1.28 as=0.14 ps=1.28 w=1 l=0.6
X5 sky130_fd_io__gpiov2_ipath_hvls_0/MODE_VCCHIB MODE_VCCHIB_N VSSD VSSD sky130_fd_pr__nfet_g5v0d10v5 ad=0.1855 pd=1.93 as=0.098 ps=0.98 w=0.7 l=0.6
X6 VDDIO_Q MODE_NORMAL_N sky130_fd_io__gpiov2_ipath_hvls_0/MODE_NORMAL VDDIO_Q sky130_fd_pr__pfet_g5v0d10v5 ad=0.14 pd=1.28 as=0.265 ps=2.53 w=1 l=0.6
X7 VCCHIB ENABLE_VDDIO_LV sky130_fd_io__gpiov2_inbuf_lvinv_x1_1/IN VCCHIB sky130_fd_pr__pfet_g5v0d10v5 ad=0.14 pd=1.28 as=0.14 ps=1.28 w=1 l=0.6
X8 VCCHIB sky130_fd_io__gpiov2_ipath_hvls_0/MODE_NORMAL sky130_fd_io__gpiov2_inbuf_lvinv_x1_0/IN VCCHIB sky130_fd_pr__pfet_g5v0d10v5 ad=0.265 pd=2.53 as=0.14 ps=1.28 w=1 l=0.6
X9 sky130_fd_io__gpiov2_ipath_hvls_0/MODE_VCCHIB MODE_VCCHIB_N VDDIO_Q VDDIO_Q sky130_fd_pr__pfet_g5v0d10v5 ad=0.265 pd=2.53 as=0.14 ps=1.28 w=1 l=0.6
X10 sky130_fd_io__gpiov2_inbuf_lvinv_x1_1/IN sky130_fd_io__gpiov2_ipath_hvls_0/MODE_VCCHIB VCCHIB VCCHIB sky130_fd_pr__pfet_g5v0d10v5 ad=0.14 pd=1.28 as=0.265 ps=2.53 w=1 l=0.6
X11 sky130_fd_io__gpiov2_inbuf_lvinv_x1_0/IN ENABLE_VDDIO_LV VCCHIB VCCHIB sky130_fd_pr__pfet_g5v0d10v5 ad=0.14 pd=1.28 as=0.14 ps=1.28 w=1 l=0.6
X12 VDDIO_Q MODE_NORMAL_N sky130_fd_io__gpiov2_ipath_hvls_0/MODE_NORMAL VDDIO_Q sky130_fd_pr__pfet_g5v0d10v5 ad=0.14 pd=1.28 as=0.265 ps=2.53 w=1 l=0.6
X13 sky130_fd_io__gpiov2_ipath_hvls_0/MODE_VCCHIB MODE_VCCHIB_N VDDIO_Q VDDIO_Q sky130_fd_pr__pfet_g5v0d10v5 ad=0.265 pd=2.53 as=0.14 ps=1.28 w=1 l=0.6
X14 VSSD ENABLE_VDDIO_LV a_10411_1726# VSSD sky130_fd_pr__nfet_g5v0d10v5 ad=0.098 pd=0.98 as=0.098 ps=0.98 w=0.7 l=0.6
X15 sky130_fd_io__gpiov2_inbuf_lvinv_x1_0/IN sky130_fd_io__gpiov2_ipath_hvls_0/MODE_NORMAL a_10763_1726# VSSD sky130_fd_pr__nfet_g5v0d10v5 ad=0.1855 pd=1.93 as=0.098 ps=0.98 w=0.7 l=0.6
X16 a_10411_1726# sky130_fd_io__gpiov2_ipath_hvls_0/MODE_VCCHIB sky130_fd_io__gpiov2_inbuf_lvinv_x1_1/IN VSSD sky130_fd_pr__nfet_g5v0d10v5 ad=0.098 pd=0.98 as=0.1855 ps=1.93 w=0.7 l=0.6
X17 a_10763_1726# ENABLE_VDDIO_LV VSSD VSSD sky130_fd_pr__nfet_g5v0d10v5 ad=0.098 pd=0.98 as=0.098 ps=0.98 w=0.7 l=0.6
.ends

.subckt sky130_fd_io__signal_5_sym_hv_local_5term GATE NWELLRING VGND NBODY IN m1_204_67#
X0 IN GATE VGND NBODY sky130_fd_pr__esd_nfet_g5v0d10v5 ad=3.727 pd=11.41 as=3.727 ps=11.41 w=5.75 l=0.6
R0 NBODY m1_534_67# sky130_fd_pr__res_generic_m1 w=0.02 l=5m
R1 NWELLRING m1_204_67# sky130_fd_pr__res_generic_m1 w=0.02 l=5m
.ends

.subckt sky130_fd_io__gpiov2_buf_localesd VTRIP_SEL_H OUT_VT VDDIO_Q VSSD OUT_H IN_H
Xsky130_fd_io__signal_5_sym_hv_local_5term_0 VSSD VDDIO_Q VSSD VSSD OUT_H VDDIO_Q
+ sky130_fd_io__signal_5_sym_hv_local_5term
Xsky130_fd_io__signal_5_sym_hv_local_5term_1 VSSD VDDIO_Q OUT_H VSSD VDDIO_Q VDDIO_Q
+ sky130_fd_io__signal_5_sym_hv_local_5term
Xsky130_fd_io__res250only_small_0 IN_H OUT_H sky130_fd_io__res250only_small
X0 OUT_H VTRIP_SEL_H OUT_VT VSSD sky130_fd_pr__nfet_g5v0d10v5 ad=0.795 pd=6.53 as=0.795 ps=6.53 w=3 l=1
.ends

.subckt sky130_fd_io__gpiov2_ipath VCCHIB DM_H_N[1] DM_H_N[0] DM_H_N[2] INP_DIS_H_N
+ IB_MODE_SEL_H IB_MODE_SEL_H_N VTRIP_SEL_H_N OUT_H ENABLE_VDDIO_LV PAD OUT VSSD MODE_VCCHIB_N
+ m1_2058_35701# VDDIO_Q
Xsky130_fd_io__gpiov2_ibuf_se_0 sky130_fd_io__gpiov2_ibuf_se_0/VTRIP_SEL_H_N VCCHIB
+ ENABLE_VDDIO_LV sky130_fd_io__gpiov2_ibuf_se_0/MODE_NORMAL_N OUT sky130_fd_io__gpiov2_ibuf_se_0/IN_VT
+ sky130_fd_io__gpiov2_ibuf_se_0/IN_H sky130_fd_io__gpiov2_ibuf_se_0/VTRIP_SEL_H MODE_VCCHIB_N
+ OUT_H PAD VDDIO_Q VSSD m2_15184_37210# sky130_fd_io__gpiov2_ibuf_se
Xsky130_fd_io__gpiov2_buf_localesd_0 sky130_fd_io__gpiov2_ibuf_se_0/VTRIP_SEL_H sky130_fd_io__gpiov2_ibuf_se_0/IN_VT
+ VDDIO_Q VSSD sky130_fd_io__gpiov2_ibuf_se_0/IN_H PAD sky130_fd_io__gpiov2_buf_localesd
X0 a_10749_140# a_11211_140# VDDIO_Q VDDIO_Q sky130_fd_pr__pfet_g5v0d10v5 ad=0.14 pd=1.28 as=0.265 ps=2.53 w=1 l=0.6
X1 VSSD a_9920_140# a_9864_832# VSSD sky130_fd_pr__nfet_g5v0d10v5 ad=0.098 pd=0.98 as=0.098 ps=0.98 w=0.7 l=0.6
X2 VSSD DM_H_N[2] a_11331_832# VSSD sky130_fd_pr__nfet_g5v0d10v5 ad=0.098 pd=0.98 as=0.098 ps=0.98 w=0.7 l=0.6
X3 a_11331_832# a_11211_140# a_10749_140# VSSD sky130_fd_pr__nfet_g5v0d10v5 ad=0.098 pd=0.98 as=0.1855 ps=1.93 w=0.7 l=0.6
X4 VDDIO_Q sky130_fd_io__gpiov2_ibuf_se_0/VTRIP_SEL_H sky130_fd_io__gpiov2_ibuf_se_0/VTRIP_SEL_H_N VDDIO_Q sky130_fd_pr__pfet_g5v0d10v5 ad=0.14 pd=1.28 as=0.265 ps=2.53 w=1 l=0.6
X5 a_9399_166# VTRIP_SEL_H_N VDDIO_Q VDDIO_Q sky130_fd_pr__pfet_g5v0d10v5 ad=0.14 pd=1.28 as=0.14 ps=1.28 w=1 l=0.6
X6 a_10573_140# a_10749_140# VDDIO_Q VDDIO_Q sky130_fd_pr__pfet_g5v0d10v5 ad=0.14 pd=1.28 as=0.14 ps=1.28 w=1 l=0.6
X7 VDDIO_Q a_10573_140# a_9920_140# VDDIO_Q sky130_fd_pr__pfet_g5v0d10v5 ad=0.14 pd=1.28 as=0.265 ps=2.53 w=1 l=0.6
X8 a_11211_140# a_11563_140# VDDIO_Q VDDIO_Q sky130_fd_pr__pfet_g5v0d10v5 ad=0.265 pd=2.53 as=0.14 ps=1.28 w=1 l=0.6
X9 VSSD a_10573_140# a_9920_140# VSSD sky130_fd_pr__nfet_g5v0d10v5 ad=0.098 pd=0.98 as=0.1855 ps=1.93 w=0.7 l=0.6
X10 a_11211_140# a_11563_140# VSSD VSSD sky130_fd_pr__nfet_g5v0d10v5 ad=0.1855 pd=1.93 as=0.098 ps=0.98 w=0.7 l=0.6
X11 sky130_fd_io__gpiov2_ibuf_se_0/VTRIP_SEL_H sky130_fd_io__gpiov2_ibuf_se_0/MODE_NORMAL_N a_9399_166# VDDIO_Q sky130_fd_pr__pfet_g5v0d10v5 ad=0.265 pd=2.53 as=0.14 ps=1.28 w=1 l=0.6
X12 VDDIO_Q INP_DIS_H_N a_10573_140# VDDIO_Q sky130_fd_pr__pfet_g5v0d10v5 ad=0.265 pd=2.53 as=0.14 ps=1.28 w=1 l=0.6
X13 MODE_VCCHIB_N a_9920_140# VDDIO_Q VDDIO_Q sky130_fd_pr__pfet_g5v0d10v5 ad=0.14 pd=1.28 as=0.14 ps=1.28 w=1 l=0.6
X14 a_9399_166# VTRIP_SEL_H_N VDDIO_Q VDDIO_Q sky130_fd_pr__pfet_g5v0d10v5 ad=0.14 pd=1.28 as=0.14 ps=1.28 w=1 l=0.6
X15 a_10573_140# a_10749_140# VDDIO_Q VDDIO_Q sky130_fd_pr__pfet_g5v0d10v5 ad=0.14 pd=1.28 as=0.14 ps=1.28 w=1 l=0.6
X16 VDDIO_Q sky130_fd_io__gpiov2_ibuf_se_0/VTRIP_SEL_H sky130_fd_io__gpiov2_ibuf_se_0/VTRIP_SEL_H_N VDDIO_Q sky130_fd_pr__pfet_g5v0d10v5 ad=0.14 pd=1.28 as=0.265 ps=2.53 w=1 l=0.6
X17 VSSD sky130_fd_io__gpiov2_ibuf_se_0/VTRIP_SEL_H sky130_fd_io__gpiov2_ibuf_se_0/VTRIP_SEL_H_N VSSD sky130_fd_pr__nfet_g5v0d10v5 ad=0.098 pd=0.98 as=0.1855 ps=1.93 w=0.7 l=0.6
X18 sky130_fd_io__gpiov2_ibuf_se_0/VTRIP_SEL_H VTRIP_SEL_H_N VSSD VSSD sky130_fd_pr__nfet_g5v0d10v5 ad=0.098 pd=0.98 as=0.098 ps=0.98 w=0.7 l=0.6
X19 a_10869_832# a_10749_140# VSSD VSSD sky130_fd_pr__nfet_g5v0d10v5 ad=0.098 pd=0.98 as=0.098 ps=0.98 w=0.7 l=0.6
X20 sky130_fd_io__gpiov2_ibuf_se_0/MODE_NORMAL_N IB_MODE_SEL_H_N VDDIO_Q VDDIO_Q sky130_fd_pr__pfet_g5v0d10v5 ad=0.14 pd=1.28 as=0.265 ps=2.53 w=1 l=0.6
X21 VDDIO_Q DM_H_N[1] a_11563_140# VDDIO_Q sky130_fd_pr__pfet_g5v0d10v5 ad=0.265 pd=2.53 as=0.14 ps=1.28 w=1 l=0.6
X22 VDDIO_Q IB_MODE_SEL_H MODE_VCCHIB_N VDDIO_Q sky130_fd_pr__pfet_g5v0d10v5 ad=0.265 pd=2.53 as=0.14 ps=1.28 w=1 l=0.6
X23 a_11563_140# DM_H_N[0] VDDIO_Q VDDIO_Q sky130_fd_pr__pfet_g5v0d10v5 ad=0.14 pd=1.28 as=0.265 ps=2.53 w=1 l=0.6
X24 sky130_fd_io__gpiov2_ibuf_se_0/VTRIP_SEL_H sky130_fd_io__gpiov2_ibuf_se_0/MODE_NORMAL_N a_9399_166# VDDIO_Q sky130_fd_pr__pfet_g5v0d10v5 ad=0.265 pd=2.53 as=0.14 ps=1.28 w=1 l=0.6
X25 VDDIO_Q INP_DIS_H_N a_10573_140# VDDIO_Q sky130_fd_pr__pfet_g5v0d10v5 ad=0.265 pd=2.53 as=0.14 ps=1.28 w=1 l=0.6
X26 VSSD sky130_fd_io__gpiov2_ibuf_se_0/MODE_NORMAL_N sky130_fd_io__gpiov2_ibuf_se_0/VTRIP_SEL_H VSSD sky130_fd_pr__nfet_g5v0d10v5 ad=0.196 pd=1.96 as=0.098 ps=0.98 w=0.7 l=0.6
X27 a_10573_140# INP_DIS_H_N a_10869_832# VSSD sky130_fd_pr__nfet_g5v0d10v5 ad=0.1855 pd=1.93 as=0.098 ps=0.98 w=0.7 l=0.6
X28 VDDIO_Q a_9920_140# sky130_fd_io__gpiov2_ibuf_se_0/MODE_NORMAL_N VDDIO_Q sky130_fd_pr__pfet_g5v0d10v5 ad=0.14 pd=1.28 as=0.14 ps=1.28 w=1 l=0.6
X29 VDDIO_Q DM_H_N[2] a_10749_140# VDDIO_Q sky130_fd_pr__pfet_g5v0d10v5 ad=0.14 pd=1.28 as=0.14 ps=1.28 w=1 l=0.6
X30 MODE_VCCHIB_N a_9920_140# VDDIO_Q VDDIO_Q sky130_fd_pr__pfet_g5v0d10v5 ad=0.14 pd=1.28 as=0.14 ps=1.28 w=1 l=0.6
X31 a_10749_140# a_11211_140# VDDIO_Q VDDIO_Q sky130_fd_pr__pfet_g5v0d10v5 ad=0.14 pd=1.28 as=0.265 ps=2.53 w=1 l=0.6
X32 a_10216_832# a_9920_140# VSSD VSSD sky130_fd_pr__nfet_g5v0d10v5 ad=0.098 pd=0.98 as=0.098 ps=0.98 w=0.7 l=0.6
X33 sky130_fd_io__gpiov2_ibuf_se_0/MODE_NORMAL_N IB_MODE_SEL_H_N VDDIO_Q VDDIO_Q sky130_fd_pr__pfet_g5v0d10v5 ad=0.14 pd=1.28 as=0.265 ps=2.53 w=1 l=0.6
X34 VDDIO_Q DM_H_N[1] a_11563_140# VDDIO_Q sky130_fd_pr__pfet_g5v0d10v5 ad=0.265 pd=2.53 as=0.14 ps=1.28 w=1 l=0.6
X35 a_9864_832# IB_MODE_SEL_H_N sky130_fd_io__gpiov2_ibuf_se_0/MODE_NORMAL_N VSSD sky130_fd_pr__nfet_g5v0d10v5 ad=0.098 pd=0.98 as=0.1855 ps=1.93 w=0.7 l=0.6
X36 VDDIO_Q a_10573_140# a_9920_140# VDDIO_Q sky130_fd_pr__pfet_g5v0d10v5 ad=0.14 pd=1.28 as=0.265 ps=2.53 w=1 l=0.6
X37 VSSD DM_H_N[1] a_11969_832# VSSD sky130_fd_pr__nfet_g5v0d10v5 ad=0.1855 pd=1.93 as=0.098 ps=0.98 w=0.7 l=0.6
X38 VDDIO_Q IB_MODE_SEL_H MODE_VCCHIB_N VDDIO_Q sky130_fd_pr__pfet_g5v0d10v5 ad=0.265 pd=2.53 as=0.14 ps=1.28 w=1 l=0.6
X39 a_11563_140# DM_H_N[0] VDDIO_Q VDDIO_Q sky130_fd_pr__pfet_g5v0d10v5 ad=0.14 pd=1.28 as=0.265 ps=2.53 w=1 l=0.6
X40 a_11211_140# a_11563_140# VDDIO_Q VDDIO_Q sky130_fd_pr__pfet_g5v0d10v5 ad=0.265 pd=2.53 as=0.14 ps=1.28 w=1 l=0.6
X41 MODE_VCCHIB_N IB_MODE_SEL_H a_10216_832# VSSD sky130_fd_pr__nfet_g5v0d10v5 ad=0.1855 pd=1.93 as=0.098 ps=0.98 w=0.7 l=0.6
X42 a_11969_832# DM_H_N[0] a_11563_140# VSSD sky130_fd_pr__nfet_g5v0d10v5 ad=0.098 pd=0.98 as=0.1855 ps=1.93 w=0.7 l=0.6
X43 VDDIO_Q a_9920_140# sky130_fd_io__gpiov2_ibuf_se_0/MODE_NORMAL_N VDDIO_Q sky130_fd_pr__pfet_g5v0d10v5 ad=0.14 pd=1.28 as=0.14 ps=1.28 w=1 l=0.6
X44 VDDIO_Q DM_H_N[2] a_10749_140# VDDIO_Q sky130_fd_pr__pfet_g5v0d10v5 ad=0.14 pd=1.28 as=0.14 ps=1.28 w=1 l=0.6
.ends

.subckt sky130_fd_io__com_ctl_ls_en_1_v2 VCC_IO VPB OUT_H_N OUT_H RST_H SET_H VPWR
+ HLD_H_N DM[1] a_1150_n777# w_1114_n948# a_1762_n1276# a_n17_1379#
X0 a_361_1391# VPWR a_128_1391# a_n17_1379# sky130_fd_pr__nfet_05v0_nvt ad=0.14 pd=1.28 as=0.265 ps=2.53 w=1 l=0.9
X1 VCC_IO a_130_181# OUT_H VCC_IO sky130_fd_pr__pfet_g5v0d10v5 ad=0.42 pd=3.28 as=0.795 ps=6.53 w=3 l=0.6
X2 a_128_1391# VPWR a_361_1391# a_n17_1379# sky130_fd_pr__nfet_05v0_nvt ad=0.265 pd=2.53 as=0.14 ps=1.28 w=1 l=0.9
X3 a_n17_1379# a_634_829# a_128_1391# a_n17_1379# sky130_fd_pr__nfet_01v8_lvt ad=0.14 pd=1.28 as=0.14 ps=1.28 w=1 l=0.15
X4 a_128_1391# a_634_829# a_n17_1379# a_n17_1379# sky130_fd_pr__nfet_01v8_lvt ad=0.14 pd=1.28 as=0.28 ps=2.56 w=1 l=0.15
X5 a_361_1391# HLD_H_N a_130_181# a_n17_1379# sky130_fd_pr__nfet_g5v0d10v5 ad=0.795 pd=6.53 as=0.795 ps=6.53 w=3 l=0.6
X6 a_361_1391# VPWR a_128_1391# a_n17_1379# sky130_fd_pr__nfet_05v0_nvt ad=0.14 pd=1.28 as=0.265 ps=2.53 w=1 l=0.9
X7 a_n17_1379# a_634_829# a_128_1391# a_n17_1379# sky130_fd_pr__nfet_01v8_lvt ad=0.14 pd=1.28 as=0.14 ps=1.28 w=1 l=0.15
X8 OUT_H_N a_65_861# VCC_IO VCC_IO sky130_fd_pr__pfet_g5v0d10v5 ad=0.795 pd=6.53 as=0.42 ps=3.28 w=3 l=0.6
X9 a_n17_1379# a_992_934# a_724_1391# a_n17_1379# sky130_fd_pr__nfet_01v8_lvt ad=0.14 pd=1.28 as=0.14 ps=1.28 w=1 l=0.15
X10 a_1150_n777# DM[1] a_992_934# w_1114_n948# sky130_fd_pr__pfet_01v8_hvt ad=0.14 pd=1.28 as=0.265 ps=2.53 w=1 l=0.25
X11 a_128_1391# a_634_829# a_n17_1379# a_n17_1379# sky130_fd_pr__nfet_01v8_lvt ad=0.14 pd=1.28 as=0.14 ps=1.28 w=1 l=0.15
X12 a_724_1391# a_992_934# a_n17_1379# a_n17_1379# sky130_fd_pr__nfet_01v8_lvt ad=0.14 pd=1.28 as=0.14 ps=1.28 w=1 l=0.15
X13 a_65_861# HLD_H_N a_957_1391# a_n17_1379# sky130_fd_pr__nfet_g5v0d10v5 ad=0.42 pd=3.28 as=0.795 ps=6.53 w=3 l=0.6
X14 OUT_H a_130_181# a_n17_1379# a_n17_1379# sky130_fd_pr__nfet_g5v0d10v5 ad=0.28 pd=2.56 as=0.14 ps=1.28 w=1 l=0.6
X15 a_n17_1379# a_992_934# a_724_1391# a_n17_1379# sky130_fd_pr__nfet_01v8_lvt ad=0.265 pd=2.53 as=0.14 ps=1.28 w=1 l=0.15
X16 a_65_861# a_130_181# VCC_IO VCC_IO sky130_fd_pr__pfet_g5v0d10v5 ad=0.19875 pd=2.03 as=0.19875 ps=2.03 w=0.75 l=0.5
X17 a_n17_1379# a_65_861# a_130_181# a_n17_1379# sky130_fd_pr__nfet_g5v0d10v5 ad=0.105 pd=1.03 as=0.19875 ps=2.03 w=0.75 l=1
X18 a_724_1391# a_992_934# a_n17_1379# a_n17_1379# sky130_fd_pr__nfet_01v8_lvt ad=0.14 pd=1.28 as=0.14 ps=1.28 w=1 l=0.15
X19 a_957_1391# VPWR a_724_1391# a_n17_1379# sky130_fd_pr__nfet_05v0_nvt ad=0.14 pd=1.28 as=0.265 ps=2.53 w=1 l=0.9
X20 a_634_829# a_992_934# a_1150_n777# w_1114_n948# sky130_fd_pr__pfet_01v8_hvt ad=0.265 pd=2.53 as=0.14 ps=1.28 w=1 l=0.25
X21 a_n17_1379# a_65_861# OUT_H_N a_n17_1379# sky130_fd_pr__nfet_g5v0d10v5 ad=0.14 pd=1.28 as=0.28 ps=2.56 w=1 l=0.6
X22 a_130_181# a_65_861# VCC_IO VCC_IO sky130_fd_pr__pfet_g5v0d10v5 ad=0.19875 pd=2.03 as=0.19875 ps=2.03 w=0.75 l=0.5
X23 a_724_1391# VPWR a_957_1391# a_n17_1379# sky130_fd_pr__nfet_05v0_nvt ad=0.265 pd=2.53 as=0.14 ps=1.28 w=1 l=0.9
X24 a_65_861# a_130_181# a_n17_1379# a_n17_1379# sky130_fd_pr__nfet_g5v0d10v5 ad=0.19875 pd=2.03 as=0.105 ps=1.03 w=0.75 l=1
X25 a_957_1391# VPWR a_724_1391# a_n17_1379# sky130_fd_pr__nfet_05v0_nvt ad=0.14 pd=1.28 as=0.265 ps=2.53 w=1 l=0.9
X26 a_130_181# SET_H a_n17_1379# a_n17_1379# sky130_fd_pr__nfet_g5v0d10v5 ad=0.795 pd=6.53 as=0.42 ps=3.28 w=3 l=0.6
X27 a_1762_n1276# DM[1] a_992_934# a_n17_1379# sky130_fd_pr__nfet_01v8 ad=0.14 pd=1.28 as=0.28 ps=2.56 w=1 l=0.25
X28 a_724_1391# VPWR a_957_1391# a_n17_1379# sky130_fd_pr__nfet_05v0_nvt ad=0.265 pd=2.53 as=0.14 ps=1.28 w=1 l=0.9
X29 a_128_1391# VPWR a_361_1391# a_n17_1379# sky130_fd_pr__nfet_05v0_nvt ad=0.265 pd=2.53 as=0.14 ps=1.28 w=1 l=0.9
X30 a_n17_1379# RST_H a_65_861# a_n17_1379# sky130_fd_pr__nfet_g5v0d10v5 ad=0.42 pd=3.28 as=0.42 ps=3.28 w=3 l=0.6
X31 a_634_829# a_992_934# a_1762_n1276# a_n17_1379# sky130_fd_pr__nfet_01v8 ad=0.28 pd=2.56 as=0.14 ps=1.28 w=1 l=0.25
.ends

.subckt sky130_fd_io__com_ctl_ls_v2 VCC_IO VPB OUT_H_N OUT_H IN RST_H SET_H VPWR HLD_H_N
+ a_n17_1379#
X0 a_361_1391# VPWR a_128_1391# a_n17_1379# sky130_fd_pr__nfet_05v0_nvt ad=0.14 pd=1.28 as=0.265 ps=2.53 w=1 l=0.9
X1 VCC_IO a_130_181# OUT_H VCC_IO sky130_fd_pr__pfet_g5v0d10v5 ad=0.42 pd=3.28 as=0.795 ps=6.53 w=3 l=0.6
X2 a_128_1391# VPWR a_361_1391# a_n17_1379# sky130_fd_pr__nfet_05v0_nvt ad=0.265 pd=2.53 as=0.14 ps=1.28 w=1 l=0.9
X3 a_n17_1379# a_634_829# a_128_1391# a_n17_1379# sky130_fd_pr__nfet_01v8_lvt ad=0.14 pd=1.28 as=0.14 ps=1.28 w=1 l=0.15
X4 a_128_1391# a_634_829# a_n17_1379# a_n17_1379# sky130_fd_pr__nfet_01v8_lvt ad=0.14 pd=1.28 as=0.28 ps=2.56 w=1 l=0.15
X5 a_361_1391# HLD_H_N a_130_181# a_n17_1379# sky130_fd_pr__nfet_g5v0d10v5 ad=0.795 pd=6.53 as=0.795 ps=6.53 w=3 l=0.6
X6 a_634_829# a_992_934# VPWR VPB sky130_fd_pr__pfet_01v8_hvt ad=0.265 pd=2.53 as=0.14 ps=1.28 w=1 l=0.25
X7 a_361_1391# VPWR a_128_1391# a_n17_1379# sky130_fd_pr__nfet_05v0_nvt ad=0.14 pd=1.28 as=0.265 ps=2.53 w=1 l=0.9
X8 a_n17_1379# a_634_829# a_128_1391# a_n17_1379# sky130_fd_pr__nfet_01v8_lvt ad=0.14 pd=1.28 as=0.14 ps=1.28 w=1 l=0.15
X9 OUT_H_N a_65_861# VCC_IO VCC_IO sky130_fd_pr__pfet_g5v0d10v5 ad=0.795 pd=6.53 as=0.42 ps=3.28 w=3 l=0.6
X10 a_n17_1379# a_992_934# a_724_1391# a_n17_1379# sky130_fd_pr__nfet_01v8_lvt ad=0.14 pd=1.28 as=0.14 ps=1.28 w=1 l=0.15
X11 a_128_1391# a_634_829# a_n17_1379# a_n17_1379# sky130_fd_pr__nfet_01v8_lvt ad=0.14 pd=1.28 as=0.14 ps=1.28 w=1 l=0.15
X12 a_724_1391# a_992_934# a_n17_1379# a_n17_1379# sky130_fd_pr__nfet_01v8_lvt ad=0.14 pd=1.28 as=0.14 ps=1.28 w=1 l=0.15
X13 a_65_861# HLD_H_N a_957_1391# a_n17_1379# sky130_fd_pr__nfet_g5v0d10v5 ad=0.42 pd=3.28 as=0.795 ps=6.53 w=3 l=0.6
X14 OUT_H a_130_181# a_n17_1379# a_n17_1379# sky130_fd_pr__nfet_g5v0d10v5 ad=0.28 pd=2.56 as=0.14 ps=1.28 w=1 l=0.6
X15 a_n17_1379# a_992_934# a_724_1391# a_n17_1379# sky130_fd_pr__nfet_01v8_lvt ad=0.265 pd=2.53 as=0.14 ps=1.28 w=1 l=0.15
X16 a_65_861# a_130_181# VCC_IO VCC_IO sky130_fd_pr__pfet_g5v0d10v5 ad=0.19875 pd=2.03 as=0.19875 ps=2.03 w=0.75 l=0.5
X17 a_n17_1379# a_65_861# a_130_181# a_n17_1379# sky130_fd_pr__nfet_g5v0d10v5 ad=0.105 pd=1.03 as=0.19875 ps=2.03 w=0.75 l=1
X18 a_724_1391# a_992_934# a_n17_1379# a_n17_1379# sky130_fd_pr__nfet_01v8_lvt ad=0.14 pd=1.28 as=0.14 ps=1.28 w=1 l=0.15
X19 VPWR IN a_992_934# VPB sky130_fd_pr__pfet_01v8_hvt ad=0.14 pd=1.28 as=0.265 ps=2.53 w=1 l=0.25
X20 a_957_1391# VPWR a_724_1391# a_n17_1379# sky130_fd_pr__nfet_05v0_nvt ad=0.14 pd=1.28 as=0.265 ps=2.53 w=1 l=0.9
X21 a_n17_1379# a_65_861# OUT_H_N a_n17_1379# sky130_fd_pr__nfet_g5v0d10v5 ad=0.14 pd=1.28 as=0.28 ps=2.56 w=1 l=0.6
X22 a_130_181# a_65_861# VCC_IO VCC_IO sky130_fd_pr__pfet_g5v0d10v5 ad=0.19875 pd=2.03 as=0.19875 ps=2.03 w=0.75 l=0.5
X23 a_n17_1379# IN a_992_934# a_n17_1379# sky130_fd_pr__nfet_01v8 ad=0.14 pd=1.28 as=0.28 ps=2.56 w=1 l=0.25
X24 a_724_1391# VPWR a_957_1391# a_n17_1379# sky130_fd_pr__nfet_05v0_nvt ad=0.265 pd=2.53 as=0.14 ps=1.28 w=1 l=0.9
X25 a_65_861# a_130_181# a_n17_1379# a_n17_1379# sky130_fd_pr__nfet_g5v0d10v5 ad=0.19875 pd=2.03 as=0.105 ps=1.03 w=0.75 l=1
X26 a_957_1391# VPWR a_724_1391# a_n17_1379# sky130_fd_pr__nfet_05v0_nvt ad=0.14 pd=1.28 as=0.265 ps=2.53 w=1 l=0.9
X27 a_634_829# a_992_934# a_n17_1379# a_n17_1379# sky130_fd_pr__nfet_01v8 ad=0.28 pd=2.56 as=0.14 ps=1.28 w=1 l=0.25
X28 a_130_181# SET_H a_n17_1379# a_n17_1379# sky130_fd_pr__nfet_g5v0d10v5 ad=0.795 pd=6.53 as=0.42 ps=3.28 w=3 l=0.6
X29 a_724_1391# VPWR a_957_1391# a_n17_1379# sky130_fd_pr__nfet_05v0_nvt ad=0.265 pd=2.53 as=0.14 ps=1.28 w=1 l=0.9
X30 a_128_1391# VPWR a_361_1391# a_n17_1379# sky130_fd_pr__nfet_05v0_nvt ad=0.265 pd=2.53 as=0.14 ps=1.28 w=1 l=0.9
X31 a_n17_1379# RST_H a_65_861# a_n17_1379# sky130_fd_pr__nfet_g5v0d10v5 ad=0.42 pd=3.28 as=0.42 ps=3.28 w=3 l=0.6
.ends

.subckt sky130_fd_io__com_ctl_lsv2 SET_H HLD_H_N VGND OUT_H OUT_H_N RST_H VPWR VCC_IO
+ m1_5675_1428# w_5775_333# w_4727_n1281# m1_5585_1428# IN
X0 OUT_H a_4739_1530# VCC_IO VCC_IO sky130_fd_pr__pfet_g5v0d10v5 ad=0.795 pd=6.53 as=0.42 ps=3.28 w=3 l=0.6
X1 OUT_H_N a_4793_n866# VGND VGND sky130_fd_pr__nfet_g5v0d10v5 ad=0.265 pd=2.53 as=0.14 ps=1.28 w=1 l=0.6
X2 a_4700_638# VPWR a_4933_638# VGND sky130_fd_pr__nfet_05v0_nvt ad=0.14 pd=1.28 as=0.14 ps=1.28 w=1 l=0.9
X3 VGND SET_H a_4739_1530# VGND sky130_fd_pr__nfet_g5v0d10v5 ad=0.42 pd=3.28 as=0.42 ps=3.28 w=3 l=0.6
X4 VGND a_4739_1530# OUT_H VGND sky130_fd_pr__nfet_g5v0d10v5 ad=0.14 pd=1.28 as=0.265 ps=2.53 w=1 l=0.6
X5 VCC_IO a_4793_n866# a_4739_1530# w_4727_n1281# sky130_fd_pr__pfet_g5v0d10v5 ad=0.19875 pd=2.03 as=0.19875 ps=2.03 w=0.75 l=0.5
X6 a_4700_968# VPWR a_4933_968# VGND sky130_fd_pr__nfet_05v0_nvt ad=0.14 pd=1.28 as=0.14 ps=1.28 w=1 l=0.9
X7 a_4933_968# a_4944_2840# VGND VGND sky130_fd_pr__nfet_01v8_lvt ad=0.14 pd=1.28 as=0.14 ps=1.28 w=1 l=0.15
X8 a_4793_n866# RST_H VGND VGND sky130_fd_pr__nfet_g5v0d10v5 ad=0.42 pd=3.28 as=0.42 ps=3.28 w=3 l=0.6
X9 VGND IN a_4944_2496# VGND sky130_fd_pr__nfet_01v8 ad=0.14 pd=1.28 as=0.265 ps=2.53 w=1 l=0.25
X10 a_4933_968# a_4944_2840# VGND VGND sky130_fd_pr__nfet_01v8_lvt ad=0.14 pd=1.28 as=0.14 ps=1.28 w=1 l=0.15
X11 a_4933_638# VPWR a_4700_638# VGND sky130_fd_pr__nfet_05v0_nvt ad=0.14 pd=1.28 as=0.265 ps=2.53 w=1 l=0.9
X12 a_4933_638# HLD_H_N a_4793_n866# VGND sky130_fd_pr__nfet_g5v0d10v5 ad=0.795 pd=6.53 as=0.42 ps=3.28 w=3 l=0.6
X13 a_4933_968# VPWR a_4700_968# VGND sky130_fd_pr__nfet_05v0_nvt ad=0.14 pd=1.28 as=0.265 ps=2.53 w=1 l=0.9
X14 a_4700_968# VPWR a_4933_968# VGND sky130_fd_pr__nfet_05v0_nvt ad=0.265 pd=2.53 as=0.14 ps=1.28 w=1 l=0.9
X15 VCC_IO a_4793_n866# OUT_H_N VCC_IO sky130_fd_pr__pfet_g5v0d10v5 ad=0.42 pd=3.28 as=0.795 ps=6.53 w=3 l=0.6
X16 VGND a_4944_2840# a_4933_968# VGND sky130_fd_pr__nfet_01v8_lvt ad=0.14 pd=1.28 as=0.14 ps=1.28 w=1 l=0.15
X17 VGND a_4944_2496# a_4700_638# VGND sky130_fd_pr__nfet_01v8_lvt ad=0.14 pd=1.28 as=0.14 ps=1.28 w=1 l=0.15
X18 VGND a_4944_2496# a_4700_638# VGND sky130_fd_pr__nfet_01v8_lvt ad=0.14 pd=1.28 as=0.14 ps=1.28 w=1 l=0.15
X19 a_4933_638# VPWR a_4700_638# VGND sky130_fd_pr__nfet_05v0_nvt ad=0.265 pd=2.53 as=0.265 ps=2.53 w=1 l=0.9
X20 VCC_IO a_4739_1530# a_4793_n866# w_4727_n1281# sky130_fd_pr__pfet_g5v0d10v5 ad=0.19875 pd=2.03 as=0.19875 ps=2.03 w=0.75 l=0.5
X21 a_4739_1530# a_4793_n866# VGND VGND sky130_fd_pr__nfet_g5v0d10v5 ad=0.19875 pd=2.03 as=0.19875 ps=2.03 w=0.75 l=1
X22 a_4944_2840# a_4944_2496# VPWR w_5775_333# sky130_fd_pr__pfet_01v8_hvt ad=0.265 pd=2.53 as=0.14 ps=1.28 w=1 l=0.25
X23 a_4933_638# VPWR a_4700_638# VGND sky130_fd_pr__nfet_05v0_nvt ad=0.265 pd=2.53 as=0.14 ps=1.28 w=1 l=0.9
X24 a_4944_2840# a_4944_2496# VGND VGND sky130_fd_pr__nfet_01v8 ad=0.265 pd=2.53 as=0.14 ps=1.28 w=1 l=0.25
X25 VGND a_4944_2840# a_4933_968# VGND sky130_fd_pr__nfet_01v8_lvt ad=0.265 pd=2.53 as=0.14 ps=1.28 w=1 l=0.15
X26 a_4793_n866# a_4739_1530# VGND VGND sky130_fd_pr__nfet_g5v0d10v5 ad=0.19875 pd=2.03 as=0.19875 ps=2.03 w=0.75 l=1
X27 a_4933_968# VPWR a_4700_968# VGND sky130_fd_pr__nfet_05v0_nvt ad=0.14 pd=1.28 as=0.14 ps=1.28 w=1 l=0.9
X28 VPWR IN a_4944_2496# w_5775_333# sky130_fd_pr__pfet_01v8_hvt ad=0.14 pd=1.28 as=0.265 ps=2.53 w=1 l=0.25
X29 a_4700_638# a_4944_2496# VGND VGND sky130_fd_pr__nfet_01v8_lvt ad=0.14 pd=1.28 as=0.14 ps=1.28 w=1 l=0.15
X30 a_4700_638# a_4944_2496# VGND VGND sky130_fd_pr__nfet_01v8_lvt ad=0.14 pd=1.28 as=0.265 ps=2.53 w=1 l=0.15
X31 a_4739_1530# HLD_H_N a_4700_968# VGND sky130_fd_pr__nfet_g5v0d10v5 ad=0.42 pd=3.28 as=0.795 ps=6.53 w=3 l=0.6
.ends

.subckt sky130_fd_io__com_ctl_ls_1v2 VCC_IO VPB OUT_H_N OUT_H IN RST_H SET_H VPWR
+ HLD_H_N a_n17_1379#
X0 a_361_1391# VPWR a_128_1391# a_n17_1379# sky130_fd_pr__nfet_05v0_nvt ad=0.14 pd=1.28 as=0.265 ps=2.53 w=1 l=0.9
X1 VCC_IO a_130_181# OUT_H VCC_IO sky130_fd_pr__pfet_g5v0d10v5 ad=0.42 pd=3.28 as=0.795 ps=6.53 w=3 l=0.6
X2 a_128_1391# VPWR a_361_1391# a_n17_1379# sky130_fd_pr__nfet_05v0_nvt ad=0.265 pd=2.53 as=0.14 ps=1.28 w=1 l=0.9
X3 a_n17_1379# a_634_829# a_128_1391# a_n17_1379# sky130_fd_pr__nfet_01v8_lvt ad=0.14 pd=1.28 as=0.14 ps=1.28 w=1 l=0.15
X4 a_128_1391# a_634_829# a_n17_1379# a_n17_1379# sky130_fd_pr__nfet_01v8_lvt ad=0.14 pd=1.28 as=0.28 ps=2.56 w=1 l=0.15
X5 a_361_1391# HLD_H_N a_130_181# a_n17_1379# sky130_fd_pr__nfet_g5v0d10v5 ad=0.795 pd=6.53 as=0.795 ps=6.53 w=3 l=0.6
X6 a_634_829# a_992_934# VPWR VPB sky130_fd_pr__pfet_01v8_hvt ad=0.265 pd=2.53 as=0.14 ps=1.28 w=1 l=0.25
X7 a_361_1391# VPWR a_128_1391# a_n17_1379# sky130_fd_pr__nfet_05v0_nvt ad=0.14 pd=1.28 as=0.265 ps=2.53 w=1 l=0.9
X8 a_n17_1379# a_634_829# a_128_1391# a_n17_1379# sky130_fd_pr__nfet_01v8_lvt ad=0.14 pd=1.28 as=0.14 ps=1.28 w=1 l=0.15
X9 OUT_H_N a_65_861# VCC_IO VCC_IO sky130_fd_pr__pfet_g5v0d10v5 ad=0.795 pd=6.53 as=0.42 ps=3.28 w=3 l=0.6
X10 a_n17_1379# a_992_934# a_724_1391# a_n17_1379# sky130_fd_pr__nfet_01v8_lvt ad=0.14 pd=1.28 as=0.14 ps=1.28 w=1 l=0.15
X11 a_128_1391# a_634_829# a_n17_1379# a_n17_1379# sky130_fd_pr__nfet_01v8_lvt ad=0.14 pd=1.28 as=0.14 ps=1.28 w=1 l=0.15
X12 a_724_1391# a_992_934# a_n17_1379# a_n17_1379# sky130_fd_pr__nfet_01v8_lvt ad=0.14 pd=1.28 as=0.14 ps=1.28 w=1 l=0.15
X13 a_65_861# HLD_H_N a_957_1391# a_n17_1379# sky130_fd_pr__nfet_g5v0d10v5 ad=0.42 pd=3.28 as=0.795 ps=6.53 w=3 l=0.6
X14 OUT_H a_130_181# a_n17_1379# a_n17_1379# sky130_fd_pr__nfet_g5v0d10v5 ad=0.28 pd=2.56 as=0.14 ps=1.28 w=1 l=0.6
X15 a_n17_1379# a_992_934# a_724_1391# a_n17_1379# sky130_fd_pr__nfet_01v8_lvt ad=0.265 pd=2.53 as=0.14 ps=1.28 w=1 l=0.15
X16 a_65_861# a_130_181# VCC_IO VCC_IO sky130_fd_pr__pfet_g5v0d10v5 ad=0.19875 pd=2.03 as=0.19875 ps=2.03 w=0.75 l=0.5
X17 a_n17_1379# a_65_861# a_130_181# a_n17_1379# sky130_fd_pr__nfet_g5v0d10v5 ad=0.105 pd=1.03 as=0.19875 ps=2.03 w=0.75 l=1
X18 a_724_1391# a_992_934# a_n17_1379# a_n17_1379# sky130_fd_pr__nfet_01v8_lvt ad=0.14 pd=1.28 as=0.14 ps=1.28 w=1 l=0.15
X19 VPWR IN a_992_934# VPB sky130_fd_pr__pfet_01v8_hvt ad=0.14 pd=1.28 as=0.265 ps=2.53 w=1 l=0.25
X20 a_957_1391# VPWR a_724_1391# a_n17_1379# sky130_fd_pr__nfet_05v0_nvt ad=0.14 pd=1.28 as=0.265 ps=2.53 w=1 l=0.9
X21 a_n17_1379# a_65_861# OUT_H_N a_n17_1379# sky130_fd_pr__nfet_g5v0d10v5 ad=0.14 pd=1.28 as=0.28 ps=2.56 w=1 l=0.6
X22 a_130_181# a_65_861# VCC_IO VCC_IO sky130_fd_pr__pfet_g5v0d10v5 ad=0.19875 pd=2.03 as=0.19875 ps=2.03 w=0.75 l=0.5
X23 a_n17_1379# IN a_992_934# a_n17_1379# sky130_fd_pr__nfet_01v8 ad=0.14 pd=1.28 as=0.28 ps=2.56 w=1 l=0.25
X24 a_724_1391# VPWR a_957_1391# a_n17_1379# sky130_fd_pr__nfet_05v0_nvt ad=0.265 pd=2.53 as=0.14 ps=1.28 w=1 l=0.9
X25 a_65_861# a_130_181# a_n17_1379# a_n17_1379# sky130_fd_pr__nfet_g5v0d10v5 ad=0.19875 pd=2.03 as=0.105 ps=1.03 w=0.75 l=1
X26 a_957_1391# VPWR a_724_1391# a_n17_1379# sky130_fd_pr__nfet_05v0_nvt ad=0.14 pd=1.28 as=0.265 ps=2.53 w=1 l=0.9
X27 a_634_829# a_992_934# a_n17_1379# a_n17_1379# sky130_fd_pr__nfet_01v8 ad=0.28 pd=2.56 as=0.14 ps=1.28 w=1 l=0.25
X28 a_130_181# SET_H a_n17_1379# a_n17_1379# sky130_fd_pr__nfet_g5v0d10v5 ad=0.795 pd=6.53 as=0.42 ps=3.28 w=3 l=0.6
X29 a_724_1391# VPWR a_957_1391# a_n17_1379# sky130_fd_pr__nfet_05v0_nvt ad=0.265 pd=2.53 as=0.14 ps=1.28 w=1 l=0.9
X30 a_128_1391# VPWR a_361_1391# a_n17_1379# sky130_fd_pr__nfet_05v0_nvt ad=0.265 pd=2.53 as=0.14 ps=1.28 w=1 l=0.9
X31 a_n17_1379# RST_H a_65_861# a_n17_1379# sky130_fd_pr__nfet_g5v0d10v5 ad=0.42 pd=3.28 as=0.42 ps=3.28 w=3 l=0.6
.ends

.subckt sky130_fd_io__gpiov2_ctl_lsbank VCC_IO STARTUP_ST_H STARTUP_RST_H HLD_I_H_N
+ OD_I_H IB_MODE_SEL_H_N DM_H_N[2] DM_H[2] DM_H[0] DM[0] INP_DIS_H INP_DIS VTRIP_SEL_H
+ VTRIP_SEL sky130_fd_io__com_ctl_ls_en_1_v2_0/a_1762_n1276# sky130_fd_io__com_ctl_lsv2_0/VCC_IO
+ DM_H[1] INP_DIS_H_N w_15552_2653# m1_2266_545# DM_H_N[1] DM[1] DM_H_N[0] VTRIP_SEL_H_N
+ IB_MODE_SEL VGND IB_MODE_SEL_H VPWR DM[2]
Xsky130_fd_io__com_ctl_ls_en_1_v2_0 VCC_IO VPWR DM_H_N[1] DM_H[1] sky130_fd_io__com_ctl_ls_en_1_v2_0/RST_H
+ sky130_fd_io__com_ctl_ls_en_1_v2_0/SET_H VPWR HLD_I_H_N DM[1] VPWR VPWR sky130_fd_io__com_ctl_ls_en_1_v2_0/a_1762_n1276#
+ VGND sky130_fd_io__com_ctl_ls_en_1_v2
Xsky130_fd_io__com_ctl_ls_v2_0 VCC_IO VPWR DM_H_N[2] DM_H[2] DM[2] sky130_fd_io__com_ctl_ls_v2_0/RST_H
+ sky130_fd_io__com_ctl_ls_v2_0/SET_H VPWR HLD_I_H_N VGND sky130_fd_io__com_ctl_ls_v2
Xsky130_fd_io__com_ctl_ls_v2_1 VCC_IO VPWR INP_DIS_H_N INP_DIS_H INP_DIS sky130_fd_io__com_ctl_ls_v2_1/RST_H
+ sky130_fd_io__com_ctl_ls_v2_1/SET_H VPWR HLD_I_H_N VGND sky130_fd_io__com_ctl_ls_v2
Xsky130_fd_io__com_ctl_ls_v2_2 VCC_IO VPWR DM_H_N[0] DM_H[0] DM[0] sky130_fd_io__com_ctl_ls_v2_2/RST_H
+ sky130_fd_io__com_ctl_ls_v2_2/SET_H VPWR HLD_I_H_N VGND sky130_fd_io__com_ctl_ls_v2
Xsky130_fd_io__com_ctl_lsv2_0 sky130_fd_io__com_ctl_lsv2_0/SET_H HLD_I_H_N VGND IB_MODE_SEL_H
+ IB_MODE_SEL_H_N sky130_fd_io__com_ctl_lsv2_0/RST_H VPWR sky130_fd_io__com_ctl_lsv2_0/VCC_IO
+ VGND VPWR w_15552_2653# VGND IB_MODE_SEL sky130_fd_io__com_ctl_lsv2
Xsky130_fd_io__com_ctl_ls_1v2_0 VCC_IO VPWR VTRIP_SEL_H_N VTRIP_SEL_H VTRIP_SEL sky130_fd_io__com_ctl_ls_1v2_0/RST_H
+ sky130_fd_io__com_ctl_ls_1v2_0/SET_H VPWR HLD_I_H_N VGND sky130_fd_io__com_ctl_ls_1v2
R0 m1_5875_412# sky130_fd_io__com_ctl_ls_v2_2/RST_H sky130_fd_pr__res_generic_m1 w=0.23 l=10m
R1 m1_6420_507# sky130_fd_io__com_ctl_ls_v2_1/SET_H sky130_fd_pr__res_generic_m1 w=0.26 l=10m
R2 sky130_fd_io__com_ctl_ls_en_1_v2_0/SET_H m1_2266_320# sky130_fd_pr__res_generic_m1 w=0.26 l=10m
R3 m1_14183_362# sky130_fd_io__com_ctl_ls_1v2_0/RST_H sky130_fd_pr__res_generic_m1 w=0.23 l=10m
R4 m2_15089_329# sky130_fd_io__com_ctl_lsv2_0/SET_H sky130_fd_pr__res_generic_m2 w=0.26 l=10m
R5 m1_6620_334# STARTUP_ST_H sky130_fd_pr__res_generic_m1 w=0.23 l=10m
R6 STARTUP_RST_H m1_6420_507# sky130_fd_pr__res_generic_m1 w=0.26 l=10m
R7 m1_5875_412# STARTUP_RST_H sky130_fd_pr__res_generic_m1 w=0.23 l=10m
R8 m1_6148_320# STARTUP_ST_H sky130_fd_pr__res_generic_m1 w=0.26 l=10m
R9 m1_10303_506# sky130_fd_io__com_ctl_ls_v2_0/SET_H sky130_fd_pr__res_generic_m1 w=0.26 l=10m
R10 sky130_fd_io__com_ctl_ls_v2_1/RST_H m1_6620_334# sky130_fd_pr__res_generic_m1 w=0.23 l=10m
R11 m1_14183_362# OD_I_H sky130_fd_pr__res_generic_m1 w=0.23 l=10m
R12 sky130_fd_io__com_ctl_ls_v2_2/SET_H m1_6148_320# sky130_fd_pr__res_generic_m1 w=0.26 l=10m
R13 OD_I_H m1_10303_543# sky130_fd_pr__res_generic_m1 w=0.26 l=10m
R14 m1_10029_412# OD_I_H sky130_fd_pr__res_generic_m1 w=0.23 l=10m
R15 m2_15027_104# sky130_fd_io__com_ctl_lsv2_0/SET_H sky130_fd_pr__res_generic_m2 w=0.26 l=10m
R16 m1_6707_412# sky130_fd_io__com_ctl_ls_v2_1/RST_H sky130_fd_pr__res_generic_m1 w=0.23 l=10m
R17 m1_6421_319# STARTUP_ST_H sky130_fd_pr__res_generic_m1 w=0.26 l=10m
R18 m2_14799_410# OD_I_H sky130_fd_pr__res_generic_m2 w=0.26 l=10m
R19 m1_14456_624# sky130_fd_io__com_ctl_ls_1v2_0/SET_H sky130_fd_pr__res_generic_m1 w=0.26 l=10m
R20 m1_5955_333# STARTUP_ST_H sky130_fd_pr__res_generic_m1 w=0.23 l=10m
R21 m1_14457_430# OD_I_H sky130_fd_pr__res_generic_m1 w=0.26 l=10m
R22 sky130_fd_io__com_ctl_ls_v2_1/SET_H m1_6421_356# sky130_fd_pr__res_generic_m1 w=0.26 l=10m
R23 m2_14799_410# sky130_fd_io__com_ctl_lsv2_0/RST_H sky130_fd_pr__res_generic_m2 w=0.26 l=10m
R24 VGND m2_15089_329# sky130_fd_pr__res_generic_m2 w=0.26 l=10m
R25 VGND m1_14456_624# sky130_fd_pr__res_generic_m1 w=0.26 l=10m
R26 sky130_fd_io__com_ctl_ls_v2_2/RST_H m1_5955_370# sky130_fd_pr__res_generic_m1 w=0.23 l=10m
R27 sky130_fd_io__com_ctl_ls_1v2_0/SET_H m1_14457_467# sky130_fd_pr__res_generic_m1 w=0.26 l=10m
R28 m1_10109_333# VGND sky130_fd_pr__res_generic_m1 w=0.23 l=10m
R29 m1_10302_320# VGND sky130_fd_pr__res_generic_m1 w=0.26 l=10m
R30 m1_2553_412# m1_2266_545# sky130_fd_pr__res_generic_m1 w=0.23 l=10m
R31 m1_2267_506# sky130_fd_io__com_ctl_ls_en_1_v2_0/SET_H sky130_fd_pr__res_generic_m1 w=0.26 l=10m
R32 sky130_fd_io__com_ctl_ls_v2_0/RST_H m1_10109_370# sky130_fd_pr__res_generic_m1 w=0.23 l=10m
R33 sky130_fd_io__com_ctl_ls_v2_0/SET_H m1_10302_320# sky130_fd_pr__res_generic_m1 w=0.26 l=10m
R34 m1_2266_545# m1_2267_543# sky130_fd_pr__res_generic_m1 w=0.26 l=10m
R35 m1_14263_617# sky130_fd_io__com_ctl_ls_1v2_0/RST_H sky130_fd_pr__res_generic_m1 w=0.23 l=10m
R36 m1_2467_333# VGND sky130_fd_pr__res_generic_m1 w=0.23 l=10m
R37 VGND m1_14263_654# sky130_fd_pr__res_generic_m1 w=0.23 l=10m
R38 sky130_fd_io__com_ctl_ls_en_1_v2_0/RST_H m1_2467_370# sky130_fd_pr__res_generic_m1 w=0.23 l=10m
R39 m1_6149_506# sky130_fd_io__com_ctl_ls_v2_2/SET_H sky130_fd_pr__res_generic_m1 w=0.26 l=10m
R40 m1_14911_509# sky130_fd_io__com_ctl_lsv2_0/RST_H sky130_fd_pr__res_generic_m1 w=0.26 l=10m
R41 m2_14990_104# OD_I_H sky130_fd_pr__res_generic_m2 w=0.26 l=10m
R42 m1_10029_412# sky130_fd_io__com_ctl_ls_v2_0/RST_H sky130_fd_pr__res_generic_m1 w=0.23 l=10m
R43 STARTUP_RST_H m1_6149_543# sky130_fd_pr__res_generic_m1 w=0.26 l=10m
R44 m1_2553_412# sky130_fd_io__com_ctl_ls_en_1_v2_0/RST_H sky130_fd_pr__res_generic_m1 w=0.23 l=10m
R45 VGND m1_14911_546# sky130_fd_pr__res_generic_m1 w=0.26 l=10m
R46 m1_2266_320# VGND sky130_fd_pr__res_generic_m1 w=0.26 l=10m
R47 m1_6744_412# STARTUP_RST_H sky130_fd_pr__res_generic_m1 w=0.23 l=10m
.ends

.subckt sky130_fd_io__com_ctl_ls set_h rst_h hld_h_n in out_h vpwr vcc_io vpb out_h_n
+ a_n17_1379#
X0 a_361_1391# vpwr a_128_1391# a_n17_1379# sky130_fd_pr__nfet_05v0_nvt ad=0.14 pd=1.28 as=0.265 ps=2.53 w=1 l=0.9
X1 vcc_io a_130_181# out_h vcc_io sky130_fd_pr__pfet_g5v0d10v5 ad=0.42 pd=3.28 as=0.795 ps=6.53 w=3 l=0.6
X2 a_128_1391# vpwr a_361_1391# a_n17_1379# sky130_fd_pr__nfet_05v0_nvt ad=0.265 pd=2.53 as=0.14 ps=1.28 w=1 l=0.9
X3 a_n17_1379# a_634_829# a_128_1391# a_n17_1379# sky130_fd_pr__nfet_01v8_lvt ad=0.14 pd=1.28 as=0.14 ps=1.28 w=1 l=0.15
X4 a_128_1391# a_634_829# a_n17_1379# a_n17_1379# sky130_fd_pr__nfet_01v8_lvt ad=0.14 pd=1.28 as=0.28 ps=2.56 w=1 l=0.15
X5 a_361_1391# hld_h_n a_130_181# a_n17_1379# sky130_fd_pr__nfet_g5v0d10v5 ad=0.795 pd=6.53 as=0.795 ps=6.53 w=3 l=0.6
X6 a_634_829# a_992_934# vpwr vpb sky130_fd_pr__pfet_01v8_hvt ad=0.265 pd=2.53 as=0.14 ps=1.28 w=1 l=0.25
X7 a_361_1391# vpwr a_128_1391# a_n17_1379# sky130_fd_pr__nfet_05v0_nvt ad=0.14 pd=1.28 as=0.265 ps=2.53 w=1 l=0.9
X8 a_n17_1379# a_634_829# a_128_1391# a_n17_1379# sky130_fd_pr__nfet_01v8_lvt ad=0.14 pd=1.28 as=0.14 ps=1.28 w=1 l=0.15
X9 out_h_n a_65_861# vcc_io vcc_io sky130_fd_pr__pfet_g5v0d10v5 ad=0.795 pd=6.53 as=0.42 ps=3.28 w=3 l=0.6
X10 a_n17_1379# a_992_934# a_724_1391# a_n17_1379# sky130_fd_pr__nfet_01v8_lvt ad=0.14 pd=1.28 as=0.14 ps=1.28 w=1 l=0.15
X11 a_128_1391# a_634_829# a_n17_1379# a_n17_1379# sky130_fd_pr__nfet_01v8_lvt ad=0.14 pd=1.28 as=0.14 ps=1.28 w=1 l=0.15
X12 a_724_1391# a_992_934# a_n17_1379# a_n17_1379# sky130_fd_pr__nfet_01v8_lvt ad=0.14 pd=1.28 as=0.14 ps=1.28 w=1 l=0.15
X13 a_65_861# hld_h_n a_957_1391# a_n17_1379# sky130_fd_pr__nfet_g5v0d10v5 ad=0.42 pd=3.28 as=0.795 ps=6.53 w=3 l=0.6
X14 out_h a_130_181# a_n17_1379# a_n17_1379# sky130_fd_pr__nfet_g5v0d10v5 ad=0.28 pd=2.56 as=0.14 ps=1.28 w=1 l=0.6
X15 a_n17_1379# a_992_934# a_724_1391# a_n17_1379# sky130_fd_pr__nfet_01v8_lvt ad=0.265 pd=2.53 as=0.14 ps=1.28 w=1 l=0.15
X16 a_65_861# a_130_181# vcc_io vcc_io sky130_fd_pr__pfet_g5v0d10v5 ad=0.19875 pd=2.03 as=0.19875 ps=2.03 w=0.75 l=0.5
X17 a_n17_1379# a_65_861# a_130_181# a_n17_1379# sky130_fd_pr__nfet_g5v0d10v5 ad=0.105 pd=1.03 as=0.19875 ps=2.03 w=0.75 l=1
X18 a_724_1391# a_992_934# a_n17_1379# a_n17_1379# sky130_fd_pr__nfet_01v8_lvt ad=0.14 pd=1.28 as=0.14 ps=1.28 w=1 l=0.15
X19 vpwr in a_992_934# vpb sky130_fd_pr__pfet_01v8_hvt ad=0.14 pd=1.28 as=0.265 ps=2.53 w=1 l=0.25
X20 a_957_1391# vpwr a_724_1391# a_n17_1379# sky130_fd_pr__nfet_05v0_nvt ad=0.14 pd=1.28 as=0.265 ps=2.53 w=1 l=0.9
X21 a_n17_1379# a_65_861# out_h_n a_n17_1379# sky130_fd_pr__nfet_g5v0d10v5 ad=0.14 pd=1.28 as=0.28 ps=2.56 w=1 l=0.6
X22 a_130_181# a_65_861# vcc_io vcc_io sky130_fd_pr__pfet_g5v0d10v5 ad=0.19875 pd=2.03 as=0.19875 ps=2.03 w=0.75 l=0.5
X23 a_n17_1379# in a_992_934# a_n17_1379# sky130_fd_pr__nfet_01v8 ad=0.14 pd=1.28 as=0.28 ps=2.56 w=1 l=0.25
X24 a_724_1391# vpwr a_957_1391# a_n17_1379# sky130_fd_pr__nfet_05v0_nvt ad=0.265 pd=2.53 as=0.14 ps=1.28 w=1 l=0.9
X25 a_65_861# a_130_181# a_n17_1379# a_n17_1379# sky130_fd_pr__nfet_g5v0d10v5 ad=0.19875 pd=2.03 as=0.105 ps=1.03 w=0.75 l=1
X26 a_957_1391# vpwr a_724_1391# a_n17_1379# sky130_fd_pr__nfet_05v0_nvt ad=0.14 pd=1.28 as=0.265 ps=2.53 w=1 l=0.9
X27 a_634_829# a_992_934# a_n17_1379# a_n17_1379# sky130_fd_pr__nfet_01v8 ad=0.28 pd=2.56 as=0.14 ps=1.28 w=1 l=0.25
X28 a_130_181# set_h a_n17_1379# a_n17_1379# sky130_fd_pr__nfet_g5v0d10v5 ad=0.795 pd=6.53 as=0.42 ps=3.28 w=3 l=0.6
X29 a_724_1391# vpwr a_957_1391# a_n17_1379# sky130_fd_pr__nfet_05v0_nvt ad=0.265 pd=2.53 as=0.14 ps=1.28 w=1 l=0.9
X30 a_128_1391# vpwr a_361_1391# a_n17_1379# sky130_fd_pr__nfet_05v0_nvt ad=0.265 pd=2.53 as=0.14 ps=1.28 w=1 l=0.9
X31 a_n17_1379# rst_h a_65_861# a_n17_1379# sky130_fd_pr__nfet_g5v0d10v5 ad=0.42 pd=3.28 as=0.42 ps=3.28 w=3 l=0.6
.ends

.subckt sky130_fd_io__com_ctl_hldv2 VCC_IO VGND HLD_I_H_N OD_I_H HLD_I_H HLD_OVR a_8218_3918#
+ a_3023_3554# m2_3556_4143# m1_3684_4201# a_2671_3554# m2_3665_4182# VPWR
Xsky130_fd_io__com_ctl_ls_0 VGND sky130_fd_io__com_ctl_ls_0/rst_h sky130_fd_io__com_ctl_ls_0/hld_h_n
+ HLD_OVR sky130_fd_io__com_ctl_ls_0/out_h VPWR VCC_IO VPWR sky130_fd_io__com_ctl_ls_0/out_h_n
+ VGND sky130_fd_io__com_ctl_ls
X0 VCC_IO sky130_fd_io__com_ctl_ls_0/hld_h_n a_3743_3580# VCC_IO sky130_fd_pr__pfet_g5v0d10v5 ad=0.14 pd=1.28 as=0.14 ps=1.28 w=1 l=0.6
X1 VGND a_3743_3580# a_4447_3580# VGND sky130_fd_pr__nfet_g5v0d10v5 ad=0.098 pd=0.98 as=0.098 ps=0.98 w=0.7 l=0.6
X2 a_4447_3580# a_3743_3580# VCC_IO VCC_IO sky130_fd_pr__pfet_g5v0d10v5 ad=0.14 pd=1.28 as=0.14 ps=1.28 w=1 l=0.6
X3 VCC_IO a_3743_3580# a_4447_3580# VCC_IO sky130_fd_pr__pfet_g5v0d10v5 ad=0.14 pd=1.28 as=0.14 ps=1.28 w=1 l=0.6
X4 VCC_IO a_3743_3580# a_4447_3580# VCC_IO sky130_fd_pr__pfet_g5v0d10v5 ad=0.14 pd=1.28 as=0.14 ps=1.28 w=1 l=0.6
X5 a_5855_3580# a_3743_3580# VCC_IO VCC_IO sky130_fd_pr__pfet_g5v0d10v5 ad=0.14 pd=1.28 as=0.14 ps=1.28 w=1 l=0.6
X6 a_5855_3580# a_3743_3580# VCC_IO VCC_IO sky130_fd_pr__pfet_g5v0d10v5 ad=0.14 pd=1.28 as=0.14 ps=1.28 w=1 l=0.6
X7 a_5855_3580# a_3743_3580# VCC_IO VCC_IO sky130_fd_pr__pfet_g5v0d10v5 ad=0.14 pd=1.28 as=0.14 ps=1.28 w=1 l=0.6
X8 VCC_IO sky130_fd_io__com_ctl_ls_0/rst_h a_7214_3580# VCC_IO sky130_fd_pr__pfet_g5v0d10v5 ad=0.14 pd=1.28 as=0.265 ps=2.53 w=1 l=0.6
X9 VCC_IO a_3743_3580# a_5855_3580# VCC_IO sky130_fd_pr__pfet_g5v0d10v5 ad=0.265 pd=2.53 as=0.14 ps=1.28 w=1 l=0.6
X10 OD_I_H a_7214_3580# VCC_IO VCC_IO sky130_fd_pr__pfet_g5v0d10v5 ad=0.14 pd=1.28 as=0.14 ps=1.28 w=1 l=0.6
X11 VCC_IO a_7214_3580# OD_I_H VCC_IO sky130_fd_pr__pfet_g5v0d10v5 ad=0.14 pd=1.28 as=0.14 ps=1.28 w=1 l=0.6
X12 VCC_IO OD_I_H a_8391_3918# VCC_IO sky130_fd_pr__pfet_g5v0d10v5 ad=0.14 pd=1.28 as=0.14 ps=1.28 w=1 l=0.6
X13 VGND a_2671_3554# sky130_fd_io__com_ctl_ls_0/rst_h VGND sky130_fd_pr__nfet_g5v0d10v5 ad=0.098 pd=0.98 as=0.1855 ps=1.93 w=0.7 l=0.6
X14 VCC_IO a_3023_3554# a_2967_3918# VCC_IO sky130_fd_pr__pfet_g5v0d10v5 ad=0.265 pd=2.53 as=0.14 ps=1.28 w=1 l=0.6
X15 VGND sky130_fd_io__com_ctl_ls_0/hld_h_n a_3743_3580# VGND sky130_fd_pr__nfet_g5v0d10v5 ad=0.098 pd=0.98 as=0.098 ps=0.98 w=0.7 l=0.6
X16 a_4447_3580# a_3743_3580# VCC_IO VCC_IO sky130_fd_pr__pfet_g5v0d10v5 ad=0.14 pd=1.28 as=0.14 ps=1.28 w=1 l=0.6
X17 a_4447_3580# a_3743_3580# VCC_IO VCC_IO sky130_fd_pr__pfet_g5v0d10v5 ad=0.14 pd=1.28 as=0.14 ps=1.28 w=1 l=0.6
X18 VCC_IO a_3743_3580# a_5855_3580# VCC_IO sky130_fd_pr__pfet_g5v0d10v5 ad=0.14 pd=1.28 as=0.14 ps=1.28 w=1 l=0.6
X19 VCC_IO a_3743_3580# a_5855_3580# VCC_IO sky130_fd_pr__pfet_g5v0d10v5 ad=0.14 pd=1.28 as=0.14 ps=1.28 w=1 l=0.6
X20 VCC_IO a_3743_3580# a_5855_3580# VCC_IO sky130_fd_pr__pfet_g5v0d10v5 ad=0.14 pd=1.28 as=0.14 ps=1.28 w=1 l=0.6
X21 a_5855_3580# a_3743_3580# VCC_IO VCC_IO sky130_fd_pr__pfet_g5v0d10v5 ad=0.14 pd=1.28 as=0.14 ps=1.28 w=1 l=0.6
X22 OD_I_H a_7214_3580# VCC_IO VCC_IO sky130_fd_pr__pfet_g5v0d10v5 ad=0.14 pd=1.28 as=0.14 ps=1.28 w=1 l=0.6
X23 VCC_IO a_7214_3580# OD_I_H VCC_IO sky130_fd_pr__pfet_g5v0d10v5 ad=0.265 pd=2.53 as=0.14 ps=1.28 w=1 l=0.6
X24 a_8391_3918# a_8271_3554# a_8218_3918# VCC_IO sky130_fd_pr__pfet_g5v0d10v5 ad=0.14 pd=1.28 as=0.265 ps=2.53 w=1 l=0.6
X25 a_8743_3918# sky130_fd_io__com_ctl_ls_0/hld_h_n VCC_IO VCC_IO sky130_fd_pr__pfet_g5v0d10v5 ad=0.14 pd=1.28 as=0.14 ps=1.28 w=1 l=0.6
X26 a_2967_3918# a_2671_3554# VCC_IO VCC_IO sky130_fd_pr__pfet_g5v0d10v5 ad=0.14 pd=1.28 as=0.14 ps=1.28 w=1 l=0.6
X27 a_3743_3580# sky130_fd_io__com_ctl_ls_0/hld_h_n VCC_IO VCC_IO sky130_fd_pr__pfet_g5v0d10v5 ad=0.14 pd=1.28 as=0.265 ps=2.53 w=1 l=0.6
X28 a_3743_3580# sky130_fd_io__com_ctl_ls_0/hld_h_n VGND VGND sky130_fd_pr__nfet_g5v0d10v5 ad=0.098 pd=0.98 as=0.098 ps=0.98 w=0.7 l=0.6
X29 a_4447_3580# a_3743_3580# VCC_IO VCC_IO sky130_fd_pr__pfet_g5v0d10v5 ad=0.14 pd=1.28 as=0.14 ps=1.28 w=1 l=0.6
X30 VCC_IO a_3743_3580# a_4447_3580# VCC_IO sky130_fd_pr__pfet_g5v0d10v5 ad=0.14 pd=1.28 as=0.14 ps=1.28 w=1 l=0.6
X31 VCC_IO a_3743_3580# a_4447_3580# VCC_IO sky130_fd_pr__pfet_g5v0d10v5 ad=0.14 pd=1.28 as=0.14 ps=1.28 w=1 l=0.6
X32 a_8271_3554# sky130_fd_io__com_ctl_ls_0/out_h a_8743_3918# VCC_IO sky130_fd_pr__pfet_g5v0d10v5 ad=0.265 pd=2.53 as=0.14 ps=1.28 w=1 l=0.6
X33 a_5855_3580# a_3743_3580# VGND VGND sky130_fd_pr__nfet_g5v0d10v5 ad=0.098 pd=0.98 as=0.098 ps=0.98 w=0.7 l=0.6
X34 VGND a_3743_3580# a_4447_3580# VGND sky130_fd_pr__nfet_g5v0d10v5 ad=0.098 pd=0.98 as=0.098 ps=0.98 w=0.7 l=0.6
X35 VCC_IO a_2671_3554# sky130_fd_io__com_ctl_ls_0/rst_h VCC_IO sky130_fd_pr__pfet_g5v0d10v5 ad=0.14 pd=1.28 as=0.265 ps=2.53 w=1 l=0.6
R0 HLD_I_H a_3743_3580# sky130_fd_pr__res_generic_m1 w=0.23 l=10m
X36 a_5855_3580# a_3743_3580# VGND VGND sky130_fd_pr__nfet_g5v0d10v5 ad=0.098 pd=0.98 as=0.098 ps=0.98 w=0.7 l=0.6
X37 VGND sky130_fd_io__com_ctl_ls_0/rst_h a_7214_3580# VGND sky130_fd_pr__nfet_g5v0d10v5 ad=0.098 pd=0.98 as=0.1855 ps=1.93 w=0.7 l=0.6
X38 sky130_fd_io__com_ctl_ls_0/hld_h_n a_2967_3918# VCC_IO VCC_IO sky130_fd_pr__pfet_g5v0d10v5 ad=0.265 pd=2.53 as=0.265 ps=2.53 w=1 l=0.6
X39 VCC_IO sky130_fd_io__com_ctl_ls_0/hld_h_n a_3743_3580# VCC_IO sky130_fd_pr__pfet_g5v0d10v5 ad=0.14 pd=1.28 as=0.14 ps=1.28 w=1 l=0.6
X40 VCC_IO sky130_fd_io__com_ctl_ls_0/hld_h_n a_3743_3580# VCC_IO sky130_fd_pr__pfet_g5v0d10v5 ad=0.14 pd=1.28 as=0.14 ps=1.28 w=1 l=0.6
X41 VGND a_7214_3580# OD_I_H VGND sky130_fd_pr__nfet_g5v0d10v5 ad=0.098 pd=0.98 as=0.098 ps=0.98 w=0.7 l=0.6
X42 VGND OD_I_H a_8218_3918# VGND sky130_fd_pr__nfet_g5v0d10v5 ad=0.098 pd=0.98 as=0.098 ps=0.98 w=0.7 l=0.6
X43 a_4447_3580# a_3743_3580# VCC_IO VCC_IO sky130_fd_pr__pfet_g5v0d10v5 ad=0.14 pd=1.28 as=0.14 ps=1.28 w=1 l=0.6
X44 VCC_IO a_3743_3580# a_4447_3580# VCC_IO sky130_fd_pr__pfet_g5v0d10v5 ad=0.14 pd=1.28 as=0.14 ps=1.28 w=1 l=0.6
X45 a_5855_3580# a_3743_3580# VCC_IO VCC_IO sky130_fd_pr__pfet_g5v0d10v5 ad=0.14 pd=1.28 as=0.14 ps=1.28 w=1 l=0.6
X46 VCC_IO a_3743_3580# a_5855_3580# VCC_IO sky130_fd_pr__pfet_g5v0d10v5 ad=0.265 pd=2.53 as=0.14 ps=1.28 w=1 l=0.6
X47 OD_I_H a_7214_3580# VCC_IO VCC_IO sky130_fd_pr__pfet_g5v0d10v5 ad=0.14 pd=1.28 as=0.14 ps=1.28 w=1 l=0.6
X48 a_2967_3918# a_3023_3554# a_2967_3580# VGND sky130_fd_pr__nfet_g5v0d10v5 ad=0.1855 pd=1.93 as=0.098 ps=0.98 w=0.7 l=0.6
X49 a_4447_3580# a_3743_3580# VGND VGND sky130_fd_pr__nfet_g5v0d10v5 ad=0.098 pd=0.98 as=0.098 ps=0.98 w=0.7 l=0.6
X50 VGND a_3743_3580# a_5855_3580# VGND sky130_fd_pr__nfet_g5v0d10v5 ad=0.098 pd=0.98 as=0.098 ps=0.98 w=0.7 l=0.6
X51 VGND a_3743_3580# a_5855_3580# VGND sky130_fd_pr__nfet_g5v0d10v5 ad=0.098 pd=0.98 as=0.098 ps=0.98 w=0.7 l=0.6
X52 OD_I_H a_7214_3580# VGND VGND sky130_fd_pr__nfet_g5v0d10v5 ad=0.098 pd=0.98 as=0.098 ps=0.98 w=0.7 l=0.6
X53 a_3743_3580# sky130_fd_io__com_ctl_ls_0/hld_h_n VCC_IO VCC_IO sky130_fd_pr__pfet_g5v0d10v5 ad=0.14 pd=1.28 as=0.14 ps=1.28 w=1 l=0.6
X54 a_8218_3918# a_8271_3554# VGND VGND sky130_fd_pr__nfet_g5v0d10v5 ad=0.098 pd=0.98 as=0.196 ps=1.96 w=0.7 l=0.6
X55 a_4447_3580# a_3743_3580# VCC_IO VCC_IO sky130_fd_pr__pfet_g5v0d10v5 ad=0.14 pd=1.28 as=0.14 ps=1.28 w=1 l=0.6
X56 a_8271_3554# sky130_fd_io__com_ctl_ls_0/hld_h_n VGND VGND sky130_fd_pr__nfet_g5v0d10v5 ad=0.098 pd=0.98 as=0.098 ps=0.98 w=0.7 l=0.6
X57 a_5855_3580# a_3743_3580# VCC_IO VCC_IO sky130_fd_pr__pfet_g5v0d10v5 ad=0.14 pd=1.28 as=0.14 ps=1.28 w=1 l=0.6
X58 VCC_IO a_3743_3580# a_5855_3580# VCC_IO sky130_fd_pr__pfet_g5v0d10v5 ad=0.14 pd=1.28 as=0.14 ps=1.28 w=1 l=0.6
X59 VCC_IO a_7214_3580# OD_I_H VCC_IO sky130_fd_pr__pfet_g5v0d10v5 ad=0.265 pd=2.53 as=0.14 ps=1.28 w=1 l=0.6
X60 a_4447_3580# a_3743_3580# VGND VGND sky130_fd_pr__nfet_g5v0d10v5 ad=0.098 pd=0.98 as=0.098 ps=0.98 w=0.7 l=0.6
X61 VGND a_3743_3580# a_4447_3580# VGND sky130_fd_pr__nfet_g5v0d10v5 ad=0.098 pd=0.98 as=0.098 ps=0.98 w=0.7 l=0.6
X62 a_5855_3580# a_3743_3580# VCC_IO VCC_IO sky130_fd_pr__pfet_g5v0d10v5 ad=0.14 pd=1.28 as=0.14 ps=1.28 w=1 l=0.6
X63 VCC_IO a_3743_3580# a_4447_3580# VCC_IO sky130_fd_pr__pfet_g5v0d10v5 ad=0.14 pd=1.28 as=0.14 ps=1.28 w=1 l=0.6
R1 a_4447_3580# HLD_I_H_N sky130_fd_pr__res_generic_m1 w=0.23 l=0.025
X64 a_2967_3918# a_2671_3554# VCC_IO VCC_IO sky130_fd_pr__pfet_g5v0d10v5 ad=0.14 pd=1.28 as=0.14 ps=1.28 w=1 l=0.6
X65 a_5855_3580# a_3743_3580# VCC_IO VCC_IO sky130_fd_pr__pfet_g5v0d10v5 ad=0.14 pd=1.28 as=0.14 ps=1.28 w=1 l=0.6
X66 VCC_IO sky130_fd_io__com_ctl_ls_0/rst_h a_7214_3580# VCC_IO sky130_fd_pr__pfet_g5v0d10v5 ad=0.14 pd=1.28 as=0.265 ps=2.53 w=1 l=0.6
R2 HLD_I_H_N a_5855_3580# sky130_fd_pr__res_generic_m1 w=0.23 l=0.025
X67 a_3743_3580# sky130_fd_io__com_ctl_ls_0/hld_h_n VCC_IO VCC_IO sky130_fd_pr__pfet_g5v0d10v5 ad=0.14 pd=1.28 as=0.265 ps=2.53 w=1 l=0.6
X68 VCC_IO a_7214_3580# OD_I_H VCC_IO sky130_fd_pr__pfet_g5v0d10v5 ad=0.14 pd=1.28 as=0.14 ps=1.28 w=1 l=0.6
X69 VCC_IO a_3743_3580# a_4447_3580# VCC_IO sky130_fd_pr__pfet_g5v0d10v5 ad=0.14 pd=1.28 as=0.14 ps=1.28 w=1 l=0.6
X70 VGND sky130_fd_io__com_ctl_ls_0/out_h a_8271_3554# VGND sky130_fd_pr__nfet_g5v0d10v5 ad=0.196 pd=1.96 as=0.098 ps=0.98 w=0.7 l=0.6
X71 VCC_IO OD_I_H a_8391_3918# VCC_IO sky130_fd_pr__pfet_g5v0d10v5 ad=0.14 pd=1.28 as=0.14 ps=1.28 w=1 l=0.6
X72 VCC_IO a_3023_3554# a_2967_3918# VCC_IO sky130_fd_pr__pfet_g5v0d10v5 ad=0.265 pd=2.53 as=0.14 ps=1.28 w=1 l=0.6
X73 sky130_fd_io__com_ctl_ls_0/hld_h_n a_2967_3918# VGND VGND sky130_fd_pr__nfet_g5v0d10v5 ad=0.1855 pd=1.93 as=0.1855 ps=1.93 w=0.7 l=0.6
X74 VGND sky130_fd_io__com_ctl_ls_0/hld_h_n a_3743_3580# VGND sky130_fd_pr__nfet_g5v0d10v5 ad=0.098 pd=0.98 as=0.098 ps=0.98 w=0.7 l=0.6
X75 VGND a_3743_3580# a_4447_3580# VGND sky130_fd_pr__nfet_g5v0d10v5 ad=0.098 pd=0.98 as=0.098 ps=0.98 w=0.7 l=0.6
X76 a_4447_3580# a_3743_3580# VGND VGND sky130_fd_pr__nfet_g5v0d10v5 ad=0.098 pd=0.98 as=0.098 ps=0.98 w=0.7 l=0.6
X77 a_4447_3580# a_3743_3580# VCC_IO VCC_IO sky130_fd_pr__pfet_g5v0d10v5 ad=0.14 pd=1.28 as=0.14 ps=1.28 w=1 l=0.6
X78 a_5855_3580# a_3743_3580# VGND VGND sky130_fd_pr__nfet_g5v0d10v5 ad=0.098 pd=0.98 as=0.098 ps=0.98 w=0.7 l=0.6
X79 VCC_IO a_2671_3554# sky130_fd_io__com_ctl_ls_0/rst_h VCC_IO sky130_fd_pr__pfet_g5v0d10v5 ad=0.14 pd=1.28 as=0.265 ps=2.53 w=1 l=0.6
X80 VCC_IO a_3743_3580# a_5855_3580# VCC_IO sky130_fd_pr__pfet_g5v0d10v5 ad=0.14 pd=1.28 as=0.14 ps=1.28 w=1 l=0.6
X81 VGND a_3743_3580# a_5855_3580# VGND sky130_fd_pr__nfet_g5v0d10v5 ad=0.1855 pd=1.93 as=0.098 ps=0.98 w=0.7 l=0.6
X82 VCC_IO a_3743_3580# a_5855_3580# VCC_IO sky130_fd_pr__pfet_g5v0d10v5 ad=0.14 pd=1.28 as=0.14 ps=1.28 w=1 l=0.6
X83 OD_I_H a_7214_3580# VGND VGND sky130_fd_pr__nfet_g5v0d10v5 ad=0.098 pd=0.98 as=0.098 ps=0.98 w=0.7 l=0.6
X84 VCC_IO sky130_fd_io__com_ctl_ls_0/hld_h_n a_3743_3580# VCC_IO sky130_fd_pr__pfet_g5v0d10v5 ad=0.14 pd=1.28 as=0.14 ps=1.28 w=1 l=0.6
X85 OD_I_H a_7214_3580# VCC_IO VCC_IO sky130_fd_pr__pfet_g5v0d10v5 ad=0.14 pd=1.28 as=0.14 ps=1.28 w=1 l=0.6
X86 a_8391_3918# a_8271_3554# a_8218_3918# VCC_IO sky130_fd_pr__pfet_g5v0d10v5 ad=0.14 pd=1.28 as=0.265 ps=2.53 w=1 l=0.6
X87 a_8743_3918# sky130_fd_io__com_ctl_ls_0/hld_h_n VCC_IO VCC_IO sky130_fd_pr__pfet_g5v0d10v5 ad=0.14 pd=1.28 as=0.14 ps=1.28 w=1 l=0.6
X88 a_4447_3580# a_3743_3580# VGND VGND sky130_fd_pr__nfet_g5v0d10v5 ad=0.098 pd=0.98 as=0.098 ps=0.98 w=0.7 l=0.6
X89 a_4447_3580# a_3743_3580# VCC_IO VCC_IO sky130_fd_pr__pfet_g5v0d10v5 ad=0.14 pd=1.28 as=0.14 ps=1.28 w=1 l=0.6
X90 VCC_IO a_3743_3580# a_4447_3580# VCC_IO sky130_fd_pr__pfet_g5v0d10v5 ad=0.14 pd=1.28 as=0.14 ps=1.28 w=1 l=0.6
X91 a_5855_3580# a_3743_3580# VGND VGND sky130_fd_pr__nfet_g5v0d10v5 ad=0.098 pd=0.98 as=0.098 ps=0.98 w=0.7 l=0.6
X92 VGND a_3743_3580# a_5855_3580# VGND sky130_fd_pr__nfet_g5v0d10v5 ad=0.098 pd=0.98 as=0.098 ps=0.98 w=0.7 l=0.6
X93 a_3743_3580# sky130_fd_io__com_ctl_ls_0/hld_h_n VCC_IO VCC_IO sky130_fd_pr__pfet_g5v0d10v5 ad=0.14 pd=1.28 as=0.14 ps=1.28 w=1 l=0.6
X94 VGND a_7214_3580# OD_I_H VGND sky130_fd_pr__nfet_g5v0d10v5 ad=0.1855 pd=1.93 as=0.098 ps=0.98 w=0.7 l=0.6
X95 a_8271_3554# sky130_fd_io__com_ctl_ls_0/out_h a_8743_3918# VCC_IO sky130_fd_pr__pfet_g5v0d10v5 ad=0.265 pd=2.53 as=0.14 ps=1.28 w=1 l=0.6
X96 a_2967_3580# a_2671_3554# VGND VGND sky130_fd_pr__nfet_g5v0d10v5 ad=0.098 pd=0.98 as=0.098 ps=0.98 w=0.7 l=0.6
X97 sky130_fd_io__com_ctl_ls_0/hld_h_n a_2967_3918# VCC_IO VCC_IO sky130_fd_pr__pfet_g5v0d10v5 ad=0.265 pd=2.53 as=0.265 ps=2.53 w=1 l=0.6
X98 a_3743_3580# sky130_fd_io__com_ctl_ls_0/hld_h_n VGND VGND sky130_fd_pr__nfet_g5v0d10v5 ad=0.098 pd=0.98 as=0.1855 ps=1.93 w=0.7 l=0.6
.ends

.subckt sky130_fd_io__gpiov2_ctl HLD_H_N OD_I_H INP_STARTUP_EN_H IB_MODE_SEL_H_N ENABLE_INP_H
+ DM[0] VTRIP_SEL_H_N DM[2] DM_H[0] DM_H[2] INP_DIS INP_DIS_H_N HLD_OVR VTRIP_SEL
+ VTRIP_SEL_H ENABLE_H DM[1] a_11799_3638# li_18199_5031# IB_MODE_SEL_H DM_H_N[0]
+ DM_H_N[1] sky130_fd_io__gpiov2_ctl_lsbank_0/sky130_fd_io__com_ctl_ls_en_1_v2_0/a_1762_n1276#
+ DM_H_N[2] DM_H[1] VPWR IB_MODE_SEL HLD_I_H_N HLD_I_OVR_H sky130_fd_io__com_ctl_hldv2_0/HLD_I_H
+ VGND VCC_IO
Xsky130_fd_io__gpiov2_ctl_lsbank_0 VCC_IO INP_STARTUP_EN_H sky130_fd_io__gpiov2_ctl_lsbank_0/STARTUP_RST_H
+ HLD_I_H_N OD_I_H IB_MODE_SEL_H_N DM_H_N[2] DM_H[2] DM_H[0] DM[0] sky130_fd_io__gpiov2_ctl_lsbank_0/INP_DIS_H
+ INP_DIS VTRIP_SEL_H VTRIP_SEL sky130_fd_io__gpiov2_ctl_lsbank_0/sky130_fd_io__com_ctl_ls_en_1_v2_0/a_1762_n1276#
+ VCC_IO DM_H[1] INP_DIS_H_N VCC_IO OD_I_H DM_H_N[1] DM[1] DM_H_N[0] VTRIP_SEL_H_N
+ IB_MODE_SEL VGND IB_MODE_SEL_H VPWR DM[2] sky130_fd_io__gpiov2_ctl_lsbank
Xsky130_fd_io__com_ctl_hldv2_0 VCC_IO VGND HLD_I_H_N OD_I_H sky130_fd_io__com_ctl_hldv2_0/HLD_I_H
+ HLD_OVR HLD_I_OVR_H HLD_H_N OD_I_H OD_I_H ENABLE_H OD_I_H VPWR sky130_fd_io__com_ctl_hldv2
X0 INP_STARTUP_EN_H a_11094_4330# VGND VGND sky130_fd_pr__nfet_g5v0d10v5 ad=0.1855 pd=1.93 as=0.098 ps=0.98 w=0.7 l=0.6
X1 VCC_IO ENABLE_INP_H a_11919_3664# VCC_IO sky130_fd_pr__pfet_g5v0d10v5 ad=0.265 pd=2.53 as=0.14 ps=1.28 w=1 l=0.6
X2 a_11919_3664# a_11799_3638# sky130_fd_io__gpiov2_ctl_lsbank_0/STARTUP_RST_H VCC_IO sky130_fd_pr__pfet_g5v0d10v5 ad=0.14 pd=1.28 as=0.265 ps=2.53 w=1 l=0.6
X3 sky130_fd_io__gpiov2_ctl_lsbank_0/STARTUP_RST_H a_11799_3638# VGND VGND sky130_fd_pr__nfet_g5v0d10v5 ad=0.098 pd=0.98 as=0.196 ps=1.96 w=0.7 l=0.6
X4 VCC_IO ENABLE_INP_H a_11919_3664# VCC_IO sky130_fd_pr__pfet_g5v0d10v5 ad=0.265 pd=2.53 as=0.14 ps=1.28 w=1 l=0.6
X5 a_11094_4330# ENABLE_INP_H VCC_IO VCC_IO sky130_fd_pr__pfet_g5v0d10v5 ad=0.14 pd=1.28 as=0.265 ps=2.53 w=1 l=0.6
X6 VGND ENABLE_INP_H sky130_fd_io__gpiov2_ctl_lsbank_0/STARTUP_RST_H VGND sky130_fd_pr__nfet_g5v0d10v5 ad=0.1855 pd=1.93 as=0.098 ps=0.98 w=0.7 l=0.6
X7 VCC_IO OD_I_H a_11094_4330# VCC_IO sky130_fd_pr__pfet_g5v0d10v5 ad=0.14 pd=1.28 as=0.14 ps=1.28 w=1 l=0.6
X8 INP_STARTUP_EN_H a_11094_4330# VCC_IO VCC_IO sky130_fd_pr__pfet_g5v0d10v5 ad=0.265 pd=2.53 as=0.14 ps=1.28 w=1 l=0.6
X9 a_11094_4330# ENABLE_INP_H VCC_IO VCC_IO sky130_fd_pr__pfet_g5v0d10v5 ad=0.14 pd=1.28 as=0.265 ps=2.53 w=1 l=0.6
X10 a_11267_4330# ENABLE_INP_H a_11094_4330# VGND sky130_fd_pr__nfet_g5v0d10v5 ad=0.098 pd=0.98 as=0.1855 ps=1.93 w=0.7 l=0.6
X11 VCC_IO OD_I_H a_11094_4330# VCC_IO sky130_fd_pr__pfet_g5v0d10v5 ad=0.14 pd=1.28 as=0.14 ps=1.28 w=1 l=0.6
X12 a_11919_3664# a_11799_3638# sky130_fd_io__gpiov2_ctl_lsbank_0/STARTUP_RST_H VCC_IO sky130_fd_pr__pfet_g5v0d10v5 ad=0.14 pd=1.28 as=0.265 ps=2.53 w=1 l=0.6
X13 VGND OD_I_H a_11267_4330# VGND sky130_fd_pr__nfet_g5v0d10v5 ad=0.098 pd=0.98 as=0.098 ps=0.98 w=0.7 l=0.6
X14 INP_STARTUP_EN_H a_11094_4330# VCC_IO VCC_IO sky130_fd_pr__pfet_g5v0d10v5 ad=0.265 pd=2.53 as=0.14 ps=1.28 w=1 l=0.6
.ends

.subckt sky130_fd_io__top_gpiov2 ANALOG_EN DM[0] DM[1] DM[2] HLD_H_N HLD_OVR INP_DIS
+ ENABLE_VDDA_H VTRIP_SEL OE_N OUT SLOW TIE_LO_ESD PAD_A_ESD_0_H ANALOG_SEL ENABLE_INP_H
+ PAD_A_ESD_1_H TIE_HI_ESD ENABLE_H IB_MODE_SEL ENABLE_VSWITCH_H VSSIO_Q PAD_A_NOESD_H
+ ANALOG_POL ENABLE_VDDIO IN IN_H sky130_fd_io__overlay_gpiov2_m4_0/sky130_fd_io__top_gpio_pad_0/b_1500_19531#
+ w_9674_16869# sky130_fd_io__gpiov2_amux_0/sky130_fd_io__amux_switch_1v2b_1/PG_AMX_VDDA_H_N
+ w_12765_16869# w_12765_14755# w_9674_14653# VDDIO_Q VSWITCH VSSA PAD VDDIO VCCHIB
+ VDDA AMUXBUS_B AMUXBUS_A VSSIO VCCD VSSD
Xsky130_fd_io__gpio_opathv2_0 sky130_fd_io__gpiov2_ctl_0/HLD_I_H_N sky130_fd_io__gpiov2_ctl_0/OD_I_H
+ SLOW VCCD sky130_fd_io__gpiov2_ctl_0/HLD_I_OVR_H li_3442_6400# li_3302_6400# li_7854_5377#
+ sky130_fd_io__gpio_opathv2_0/sky130_fd_io__gpiov2_octl_dat_0/sky130_fd_io__gpiov2_obpredrvr_0/sky130_fd_io__gpiov2_pdpredrvr_strong_0/sky130_fd_io__gpiov2_octl_mux_0/Y_H
+ sky130_fd_io__gpiov2_ctl_0/DM_H[0] sky130_fd_io__gpiov2_ctl_0/DM_H_N[0] li_7943_6398#
+ sky130_fd_io__gpiov2_ctl_0/DM_H[2] sky130_fd_io__gpiov2_ctl_0/DM_H_N[1] VSSD PAD
+ TIE_LO_ESD li_4745_6400# li_7636_6398# sky130_fd_io__gpio_opathv2_0/sky130_fd_io__gpio_odrvrv2_0/PU_H_N[2]
+ sky130_fd_io__gpiov2_ctl_0/VTRIP_SEL_H_N li_5278_5352# TIE_HI_ESD VSSD sky130_fd_io__gpiov2_ctl_0/DM_H[1]
+ PAD li_5245_3919# li_9062_7268# sky130_fd_io__gpiov2_ctl_0/DM_H_N[2] li_2678_6400#
+ VDDA li_10974_4971# VCCHIB OE_N OUT VSSD VDDIO sky130_fd_io__gpio_opathv2_0/sky130_fd_io__gpiov2_octl_dat_0/sky130_fd_io__gpiov2_obpredrvr_0/sky130_fd_io__gpio_pupredrvr_strongv2_0/sky130_fd_io__feascom_pupredrvr_nbiasv2_0/NBIAS
+ li_3958_5352# li_3334_5352# VSSIO sky130_fd_io__gpio_opathv2
Xsky130_fd_io__gpiov2_amux_0 sky130_fd_io__gpiov2_amux_0/sky130_fd_io__gpiov2_amux_ctl_logic_0/sky130_fd_io__gpiov2_amux_decoder_0/sky130_fd_io__nor2_1_0/B
+ sky130_fd_io__gpiov2_amux_0/sky130_fd_io__gpiov2_amux_ctl_logic_0/sky130_fd_io__gpiov2_amux_decoder_0/sky130_fd_io__inv_1_9/Y
+ sky130_fd_io__gpiov2_amux_0/sky130_fd_io__res75only_small_13/ROUT sky130_fd_io__gpiov2_amux_0/sky130_fd_io__gpiov2_amux_ctl_logic_0/sky130_fd_io__gpiov2_amux_decoder_0/sky130_fd_io__inv_1_6/Y
+ sky130_fd_io__gpiov2_amux_0/sky130_fd_io__gpiov2_amux_ctl_logic_0/sky130_fd_io__gpiov2_amux_decoder_0/sky130_fd_io__inv_1_13/Y
+ sky130_fd_io__gpiov2_amux_0/sky130_fd_io__res75only_small_0/ROUT ANALOG_EN ANALOG_POL
+ sky130_fd_io__gpiov2_amux_0/sky130_fd_io__gpiov2_amux_ctl_logic_0/sky130_fd_io__gpiov2_amux_decoder_0/sky130_fd_io__nor2_1_3/B
+ sky130_fd_io__gpiov2_amux_0/sky130_fd_io__gpiov2_amux_ctl_logic_0/sky130_fd_io__gpiov2_amux_decoder_0/sky130_fd_io__inv_1_0/Y
+ sky130_fd_io__gpiov2_amux_0/sky130_fd_io__res75only_small_10/ROUT sky130_fd_io__gpiov2_amux_0/sky130_fd_io__gpiov2_amux_ctl_logic_0/sky130_fd_io__gpiov2_amux_decoder_0/sky130_fd_io__inv_1_8/A
+ sky130_fd_io__gpiov2_amux_0/sky130_fd_io__gpiov2_amux_ctl_logic_0/sky130_fd_io__gpiov2_amux_decoder_0/sky130_fd_io__inv_1_13/Y
+ sky130_fd_io__gpiov2_amux_0/sky130_fd_io__res75only_small_10/ROUT sky130_fd_io__gpiov2_amux_0/sky130_fd_io__amux_switch_1v2b_1/PG_AMX_VDDA_H_N
+ sky130_fd_io__gpiov2_amux_0/sky130_fd_io__res75only_small_3/ROUT sky130_fd_io__gpiov2_amux_0/sky130_fd_io__res75only_small_7/ROUT
+ sky130_fd_io__gpiov2_amux_0/sky130_fd_io__amux_switch_1v2b_0/NG_PAD_VPMP_H sky130_fd_io__gpiov2_amux_0/sky130_fd_io__gpiov2_amux_ctl_logic_0/sky130_fd_io__gpiov2_amux_decoder_0/sky130_fd_io__inv_1_2/Y
+ sky130_fd_io__gpiov2_amux_0/sky130_fd_io__res75only_small_3/ROUT sky130_fd_io__gpiov2_amux_0/sky130_fd_io__gpiov2_amux_ctl_logic_0/sky130_fd_io__gpiov2_amux_decoder_0/sky130_fd_io__nand2_1_1/B
+ sky130_fd_io__gpiov2_amux_0/sky130_fd_io__amux_switch_1v2b_0/NG_AMX_VPMP_H sky130_fd_io__gpiov2_amux_0/sky130_fd_io__gpiov2_amux_ctl_logic_0/sky130_fd_io__gpiov2_amux_decoder_0/sky130_fd_io__inv_1_13/Y
+ sky130_fd_io__gpiov2_amux_0/sky130_fd_io__res75only_small_0/ROUT sky130_fd_io__gpiov2_amux_0/sky130_fd_io__gpiov2_amux_ctl_logic_0/sky130_fd_io__gpiov2_amux_decoder_0/sky130_fd_io__nor2_1_2/Y
+ sky130_fd_io__gpiov2_amux_0/sky130_fd_io__res75only_small_13/ROUT PAD sky130_fd_io__gpiov2_amux_0/sky130_fd_io__gpiov2_amux_ctl_logic_0/sky130_fd_io__gpiov2_amux_decoder_0/sky130_fd_io__nor2_1_1/Y
+ sky130_fd_io__gpiov2_amux_0/sky130_fd_io__res75only_small_4/ROUT sky130_fd_io__gpiov2_amux_0/sky130_fd_io__gpiov2_amux_ctl_logic_0/sky130_fd_io__gpiov2_amux_decoder_0/sky130_fd_io__inv_1_3/Y
+ sky130_fd_io__gpiov2_amux_0/sky130_fd_io__gpiov2_amux_ctl_logic_0/sky130_fd_io__gpiov2_amux_decoder_0/sky130_fd_io__inv_1_4/Y
+ sky130_fd_io__gpiov2_amux_0/sky130_fd_io__gpiov2_amux_ctl_logic_0/sky130_fd_io__gpiov2_amux_decoder_0/sky130_fd_io__inv_1_11/Y
+ sky130_fd_io__gpiov2_amux_0/sky130_fd_io__gpiov2_amux_ctl_logic_0/sky130_fd_io__gpiov2_amux_decoder_0/sky130_fd_io__inv_1_5/Y
+ sky130_fd_io__gpiov2_amux_0/sky130_fd_io__gpiov2_amux_ctl_logic_0/sky130_fd_io__gpiov2_amux_decoder_0/sky130_fd_io__nor2_1_3/Y
+ sky130_fd_io__gpiov2_amux_0/sky130_fd_io__gpiov2_amux_ctl_logic_0/sky130_fd_io__gpiov2_amux_decoder_0/sky130_fd_io__nor2_1_0/B
+ sky130_fd_io__gpiov2_amux_0/sky130_fd_io__amux_switch_1v2b_0/PG_AMX_VDDA_H_N PAD
+ sky130_fd_io__gpiov2_amux_0/sky130_fd_io__gpiov2_amux_ctl_logic_0/sky130_fd_io__gpiov2_amux_decoder_0/sky130_fd_io__inv_1_6/Y
+ sky130_fd_io__gpiov2_amux_0/sky130_fd_io__gpiov2_amux_ctl_logic_0/sky130_fd_io__gpiov2_amux_decoder_0/sky130_fd_io__inv_1_6/Y
+ sky130_fd_io__gpiov2_amux_0/sky130_fd_io__gpiov2_amux_ctl_logic_0/sky130_fd_io__gpiov2_amux_decoder_0/sky130_fd_io__inv_1_11/A
+ sky130_fd_io__gpiov2_amux_0/sky130_fd_io__amux_switch_1v2b_1/PG_PAD_VDDIOQ_H_N sky130_fd_io__gpiov2_amux_0/sky130_fd_io__gpiov2_amux_ctl_logic_0/sky130_fd_io__gpiov2_amux_decoder_0/sky130_fd_io__inv_1_4/Y
+ sky130_fd_io__gpiov2_amux_0/sky130_fd_io__gpiov2_amux_ctl_logic_0/sky130_fd_io__gpiov2_amux_decoder_0/sky130_fd_io__nor2_1_2/B
+ sky130_fd_io__gpiov2_amux_0/sky130_fd_io__gpiov2_amux_ctl_logic_0/sky130_fd_io__gpiov2_amux_decoder_0/sky130_fd_io__inv_1_8/Y
+ sky130_fd_io__gpiov2_amux_0/sky130_fd_io__gpiov2_amux_ctl_logic_0/sky130_fd_io__gpiov2_amux_decoder_0/sky130_fd_io__inv_1_6/Y
+ sky130_fd_io__gpiov2_amux_0/sky130_fd_io__gpiov2_amux_ctl_logic_0/sky130_fd_io__gpiov2_amux_decoder_0/sky130_fd_io__inv_1_12/Y
+ VDDA sky130_fd_io__gpiov2_amux_0/sky130_fd_io__res75only_small_8/ROUT sky130_fd_io__gpiov2_amux_0/sky130_fd_io__gpiov2_amux_ctl_logic_0/sky130_fd_io__gpiov2_amux_decoder_0/sky130_fd_io__inv_1_5/A
+ VSSA sky130_fd_io__gpiov2_amux_0/sky130_fd_io__amux_switch_1v2b_1/NG_PAD_VPMP_H
+ sky130_fd_io__gpiov2_amux_0/sky130_fd_io__gpiov2_amux_ctl_logic_0/sky130_fd_io__gpiov2_amux_decoder_0/sky130_fd_io__nor2_1_2/B
+ sky130_fd_io__gpiov2_amux_0/sky130_fd_io__res75only_small_13/ROUT sky130_fd_io__gpiov2_amux_0/sky130_fd_io__res75only_small_5/ROUT
+ sky130_fd_io__gpiov2_amux_0/sky130_fd_io__gpiov2_amux_ctl_logic_0/sky130_fd_io__gpiov2_amux_decoder_0/sky130_fd_io__inv_1_14/Y
+ sky130_fd_io__gpiov2_amux_0/sky130_fd_io__amux_switch_1v2b_1/NG_AMX_VPMP_H PAD VSSA
+ sky130_fd_io__gpiov2_amux_0/sky130_fd_io__gpiov2_amux_ctl_logic_0/sky130_fd_io__gpiov2_amux_decoder_0/sky130_fd_io__inv_1_7/A
+ sky130_fd_io__gpiov2_amux_0/sky130_fd_io__gpiov2_amux_ctl_logic_0/sky130_fd_io__gpiov2_amux_decoder_0/sky130_fd_io__inv_1_11/A
+ sky130_fd_io__gpiov2_amux_0/sky130_fd_io__res75only_small_10/ROUT sky130_fd_io__gpiov2_amux_0/sky130_fd_io__gpiov2_amux_ctl_logic_0/sky130_fd_io__gpiov2_amux_decoder_0/sky130_fd_io__nor2_1_1/B
+ sky130_fd_io__gpiov2_amux_0/sky130_fd_io__gpiov2_amux_ctl_logic_0/sky130_fd_io__gpiov2_amux_decoder_0/sky130_fd_io__inv_1_12/Y
+ sky130_fd_io__gpiov2_amux_0/sky130_fd_io__gpiov2_amux_ctl_logic_0/sky130_fd_io__gpiov2_amux_decoder_0/sky130_fd_io__inv_1_1/Y
+ sky130_fd_io__gpiov2_amux_0/sky130_fd_io__gpiov2_amux_ctl_logic_0/sky130_fd_io__gpiov2_amux_decoder_0/sky130_fd_io__inv_1_9/A
+ sky130_fd_io__gpiov2_amux_0/sky130_fd_io__gpiov2_amux_ctl_logic_0/sky130_fd_io__gpiov2_amux_decoder_0/sky130_fd_io__nand2_1_1/B
+ ANALOG_SEL sky130_fd_io__gpiov2_amux_0/sky130_fd_io__gpiov2_amux_ctl_logic_0/sky130_fd_io__gpiov2_amux_decoder_0/sky130_fd_io__inv_1_2/A
+ VCCD sky130_fd_io__gpiov2_amux_0/sky130_fd_io__gpiov2_amux_ctl_logic_0/sky130_fd_io__gpiov2_amux_decoder_0/sky130_fd_io__inv_1_4/Y
+ PAD sky130_fd_io__gpiov2_amux_0/sky130_fd_io__gpiov2_amux_ctl_logic_0/sky130_fd_io__gpiov2_amux_decoder_0/sky130_fd_io__inv_1_3/Y
+ sky130_fd_io__gpiov2_amux_0/sky130_fd_io__gpiov2_amux_ctl_logic_0/sky130_fd_io__gpiov2_amux_decoder_0/sky130_fd_io__inv_1_11/A
+ sky130_fd_io__gpiov2_amux_0/sky130_fd_io__gpiov2_amux_ctl_logic_0/sky130_fd_io__gpiov2_amux_decoder_0/sky130_fd_io__inv_1_7/Y
+ sky130_fd_io__gpiov2_amux_0/sky130_fd_io__amux_switch_1v2b_0/PG_PAD_VDDIOQ_H_N VSSD
+ sky130_fd_io__gpiov2_amux_0/sky130_fd_io__res75only_small_9/ROUT w_9674_16869# sky130_fd_io__gpiov2_amux_0/sky130_fd_io__gpiov2_amux_ctl_logic_0/sky130_fd_io__gpiov2_amux_decoder_0/sky130_fd_io__nor2_1_2/Y
+ AMUXBUS_A sky130_fd_io__gpiov2_amux_0/sky130_fd_io__gpiov2_amux_ctl_logic_0/sky130_fd_io__gpiov2_amux_decoder_0/sky130_fd_io__inv_1_5/Y
+ VCCD sky130_fd_io__gpiov2_amux_0/sky130_fd_io__gpiov2_amux_ctl_logic_0/sky130_fd_io__gpiov2_amux_decoder_0/sky130_fd_io__inv_1_2/A
+ sky130_fd_io__gpiov2_amux_0/sky130_fd_io__res75only_small_10/ROUT sky130_fd_io__gpiov2_amux_0/sky130_fd_io__res75only_small_6/ROUT
+ VSSA AMUXBUS_B sky130_fd_io__gpiov2_amux_0/sky130_fd_io__gpiov2_amux_ctl_logic_0/sky130_fd_io__gpiov2_amux_decoder_0/sky130_fd_io__nor2_1_1/B
+ sky130_fd_io__gpiov2_amux_0/sky130_fd_io__res75only_small_10/ROUT sky130_fd_io__gpiov2_amux_0/sky130_fd_io__gpiov2_amux_ctl_logic_0/sky130_fd_io__gpiov2_amux_decoder_0/sky130_fd_io__inv_1_7/Y
+ sky130_fd_io__gpiov2_amux_0/sky130_fd_io__res75only_small_3/ROUT sky130_fd_io__gpiov2_amux_0/sky130_fd_io__gpiov2_amux_ctl_logic_0/sky130_fd_io__gpiov2_amux_decoder_0/sky130_fd_io__inv_1_6/Y
+ w_12765_16869# VCCD sky130_fd_io__gpiov2_amux_0/sky130_fd_io__gpiov2_amux_ctl_logic_0/sky130_fd_io__gpiov2_amux_decoder_0/sky130_fd_io__inv_1_11/Y
+ w_9674_14653# w_12765_14755# sky130_fd_io__gpiov2_amux_0/sky130_fd_io__res75only_small_3/ROUT
+ VSSD VSSD sky130_fd_io__gpiov2_amux_0/sky130_fd_io__res75only_small_3/ROUT OUT VDDIO_Q
+ PAD sky130_fd_io__gpiov2_amux_0/sky130_fd_io__res75only_small_0/ROUT VCCD sky130_fd_io__gpiov2_amux_0/sky130_fd_io__gpiov2_amux_ctl_logic_0/sky130_fd_io__gpiov2_amux_decoder_0/sky130_fd_io__nor2_1_3/B
+ VSSD VDDIO_Q VSSD sky130_fd_io__gpiov2_amux
Xsky130_fd_io__res75only_small_0 PAD_A_ESD_1_H sky130_fd_io__res75only_small_1/PAD
+ sky130_fd_io__res75only_small
Xsky130_fd_io__res75only_small_1 sky130_fd_io__res75only_small_1/PAD PAD sky130_fd_io__res75only_small
Xsky130_fd_io__res75only_small_2 PAD_A_ESD_0_H sky130_fd_io__res75only_small_3/PAD
+ sky130_fd_io__res75only_small
Xsky130_fd_io__res75only_small_3 sky130_fd_io__res75only_small_3/PAD PAD sky130_fd_io__res75only_small
Xsky130_fd_io__gpiov2_ipath_0 VCCHIB sky130_fd_io__gpiov2_ctl_0/DM_H_N[1] sky130_fd_io__gpiov2_ctl_0/DM_H_N[0]
+ sky130_fd_io__gpiov2_ctl_0/DM_H_N[2] sky130_fd_io__gpiov2_ctl_0/INP_DIS_H_N sky130_fd_io__gpiov2_ctl_0/IB_MODE_SEL_H
+ sky130_fd_io__gpiov2_ctl_0/IB_MODE_SEL_H_N sky130_fd_io__gpiov2_ctl_0/VTRIP_SEL_H_N
+ IN_H ENABLE_VDDIO PAD IN VSSD sky130_fd_io__gpiov2_ipath_0/MODE_VCCHIB_N VDDIO VDDIO_Q
+ sky130_fd_io__gpiov2_ipath
Xsky130_fd_io__gpiov2_ctl_0 HLD_H_N sky130_fd_io__gpiov2_ctl_0/OD_I_H sky130_fd_io__gpiov2_ctl_0/INP_STARTUP_EN_H
+ sky130_fd_io__gpiov2_ctl_0/IB_MODE_SEL_H_N ENABLE_INP_H DM[0] sky130_fd_io__gpiov2_ctl_0/VTRIP_SEL_H_N
+ DM[2] sky130_fd_io__gpiov2_ctl_0/DM_H[0] sky130_fd_io__gpiov2_ctl_0/DM_H[2] INP_DIS
+ sky130_fd_io__gpiov2_ctl_0/INP_DIS_H_N HLD_OVR VTRIP_SEL sky130_fd_io__gpiov2_ctl_0/VTRIP_SEL_H
+ ENABLE_H DM[1] ENABLE_H PAD sky130_fd_io__gpiov2_ctl_0/IB_MODE_SEL_H sky130_fd_io__gpiov2_ctl_0/DM_H_N[0]
+ sky130_fd_io__gpiov2_ctl_0/DM_H_N[1] VSSD sky130_fd_io__gpiov2_ctl_0/DM_H_N[2] sky130_fd_io__gpiov2_ctl_0/DM_H[1]
+ VCCD IB_MODE_SEL sky130_fd_io__gpiov2_ctl_0/HLD_I_H_N sky130_fd_io__gpiov2_ctl_0/HLD_I_OVR_H
+ sky130_fd_io__gpiov2_ctl_0/sky130_fd_io__com_ctl_hldv2_0/HLD_I_H VSSD VDDIO_Q sky130_fd_io__gpiov2_ctl
X0 sky130_fd_io__gpiov2_amux_0/sky130_fd_io__res75only_small_5/ROUT a_2250_17651# VDDIO_Q VDDIO_Q sky130_fd_pr__pfet_g5v0d10v5 ad=2.1 pd=15.28 as=4.2 ps=30.56 w=15 l=0.5
X1 a_14092_2778# a_13902_2778# VDDIO_Q VDDIO_Q sky130_fd_pr__pfet_g5v0d10v5 ad=0.19875 pd=2.03 as=0.19875 ps=2.03 w=0.75 l=0.5
X2 VCCD a_6895_11435# a_7015_11461# VCCD sky130_fd_pr__pfet_g5v0d10v5 ad=0.14 pd=1.28 as=0.14 ps=1.28 w=1 l=0.6
X3 a_3462_14827# a_3642_14801# a_620_18182# VSSA sky130_fd_pr__nfet_g5v0d10v5 ad=0.42 pd=3.28 as=0.795 ps=6.53 w=3 l=0.5
X4 a_10924_13064# a_334_12102# a_10768_13064# VSSD sky130_fd_pr__nfet_g5v0d10v5 ad=0.7 pd=5.28 as=0.7 ps=5.28 w=5 l=0.5
X5 a_10350_10272# VCCD a_10583_10272# VSSD sky130_fd_pr__nfet_05v0_nvt ad=0.265 pd=2.53 as=0.14 ps=1.28 w=1 l=0.9
X6 VSSA a_377_12820# a_2162_14426# VSSA sky130_fd_pr__nfet_g5v0d10v5 ad=0.21 pd=1.78 as=0.21 ps=1.78 w=1.5 l=0.5
X7 VSSA a_478_17182# sky130_fd_io__gpiov2_amux_0/sky130_fd_io__amux_switch_1v2b_0/NG_AMX_VPMP_H VSSA sky130_fd_pr__nfet_g5v0d10v5 ad=0.14 pd=1.28 as=0.265 ps=2.53 w=1 l=0.5
X8 VSSD a_231_9686# a_178_9778# VSSD sky130_fd_pr__nfet_g5v0d10v5 ad=0.21 pd=1.78 as=0.3975 ps=3.53 w=1.5 l=0.5
X9 a_9877_11799# a_8765_11461# a_8067_11435# VCCD sky130_fd_pr__pfet_g5v0d10v5 ad=0.14 pd=1.28 as=0.265 ps=2.53 w=1 l=0.6
X10 sky130_fd_io__gpiov2_amux_0/sky130_fd_io__amux_switch_1v2b_0/NG_PAD_VPMP_H a_1225_12852# VSSA VSSA sky130_fd_pr__nfet_g5v0d10v5 ad=0.0588 pd=0.7 as=0.0588 ps=0.7 w=0.42 l=0.6
X11 a_10768_13064# a_2250_17651# sky130_fd_io__gpiov2_amux_0/sky130_fd_io__gpiov2_amux_ctl_logic_0/sky130_fd_io__gpiov2_amux_decoder_0/sky130_fd_io__inv_1_9/A VSSD sky130_fd_pr__nfet_g5v0d10v5 ad=0.7 pd=5.28 as=1.325 ps=10.53 w=5 l=0.5
X12 a_2159_13760# a_689_12820# a_1024_12357# VSSA sky130_fd_pr__nfet_g5v0d10v5 ad=0.3975 pd=3.53 as=0.21 ps=1.78 w=1.5 l=0.5
X13 VCCD sky130_fd_io__gpiov2_amux_0/sky130_fd_io__gpiov2_amux_ctl_logic_0/sky130_fd_io__gpiov2_amux_decoder_0/sky130_fd_io__inv_1_5/A a_12443_12112# VCCD sky130_fd_pr__pfet_g5v0d10v5 ad=0.15455 pd=1.37 as=0.14 ps=1.28 w=1 l=0.6
X14 a_9406_11799# sky130_fd_io__gpiov2_amux_0/sky130_fd_io__amux_switch_1v2b_0/NG_PAD_VPMP_H VCCD VCCD sky130_fd_pr__pfet_g5v0d10v5 ad=0.14 pd=1.28 as=0.265 ps=2.53 w=1 l=0.6
X15 VDDA a_184_18182# sky130_fd_io__gpiov2_amux_0/sky130_fd_io__amux_switch_1v2b_1/PG_AMX_VDDA_H_N VDDA sky130_fd_pr__pfet_g5v0d10v5 ad=0.265 pd=2.53 as=0.14 ps=1.28 w=1 l=0.5
X16 VSWITCH a_1024_12357# a_387_12076# VSWITCH sky130_fd_pr__pfet_g5v0d10v5 ad=0.19875 pd=2.03 as=0.105 ps=1.03 w=0.75 l=2
X17 VCCD sky130_fd_io__gpiov2_amux_0/sky130_fd_io__gpiov2_amux_ctl_logic_0/sky130_fd_io__gpiov2_amux_decoder_0/sky130_fd_io__nor2_1_1/Y sky130_fd_io__gpiov2_amux_0/sky130_fd_io__gpiov2_amux_ctl_logic_0/sky130_fd_io__gpiov2_amux_decoder_0/sky130_fd_io__inv_1_5/A VCCD sky130_fd_pr__pfet_g5v0d10v5 ad=0.14 pd=1.28 as=0.14 ps=1.28 w=1 l=0.6
X18 VDDA a_497_17084# a_229_14828# VDDA sky130_fd_pr__pfet_g5v0d10v5 ad=0.0588 pd=0.7 as=0.1113 ps=1.37 w=0.42 l=1
X19 a_324_14186# a_689_12820# a_789_14186# VSSA sky130_fd_pr__nfet_g5v0d10v5 ad=0.3975 pd=3.53 as=0.21 ps=1.78 w=1.5 l=0.5
X20 a_620_17850# a_178_9778# a_2080_14827# VSSA sky130_fd_pr__nfet_g5v0d10v5 ad=0.795 pd=6.53 as=0.42 ps=3.28 w=3 l=0.5
X21 a_10406_10767# a_7173_10183# VDDIO_Q VDDIO_Q sky130_fd_pr__pfet_g5v0d10v5 ad=0.1855 pd=1.93 as=0.098 ps=0.98 w=0.7 l=0.6
X22 sky130_fd_io__gpiov2_amux_0/sky130_fd_io__amux_switch_1v2b_1/PG_AMX_VDDA_H_N a_184_18182# VDDA VDDA sky130_fd_pr__pfet_g5v0d10v5 ad=0.14 pd=1.28 as=0.265 ps=2.53 w=1 l=0.5
X23 w_12765_16869# sky130_fd_io__gpiov2_ctl_0/sky130_fd_io__com_ctl_hldv2_0/HLD_I_H VSSA VSSA sky130_fd_pr__nfet_g5v0d10v5 ad=0.1176 pd=1.4 as=0.1176 ps=1.4 w=0.42 l=0.5
X24 a_1072_12852# VCCD a_593_13378# VSSA sky130_fd_pr__nfet_05v0_nvt ad=0.265 pd=2.53 as=0.14 ps=1.28 w=1 l=0.9
X25 a_789_14186# a_689_12820# a_324_14186# VSSA sky130_fd_pr__nfet_g5v0d10v5 ad=0.21 pd=1.78 as=0.21 ps=1.78 w=1.5 l=0.5
X26 VSSA a_478_17182# a_184_18182# VSSA sky130_fd_pr__nfet_g5v0d10v5 ad=0.14 pd=1.28 as=0.265 ps=2.53 w=1 l=0.5
X27 w_9674_14653# a_6367_11435# sky130_fd_io__gpiov2_amux_0/sky130_fd_io__res75only_small_6/ROUT VSSA sky130_fd_pr__nfet_g5v0d10v5 ad=0.84 pd=6.56 as=0.84 ps=6.56 w=3 l=0.5
X28 a_620_18182# a_184_18182# VDDA VDDA sky130_fd_pr__pfet_g5v0d10v5 ad=0.1113 pd=1.37 as=0.0588 ps=0.7 w=0.42 l=1
X29 a_1079_9778# a_282_14802# a_926_9778# VSSD sky130_fd_pr__nfet_g5v0d10v5 ad=0.21 pd=1.78 as=0.3975 ps=3.53 w=1.5 l=0.5
X30 a_6367_11435# a_6543_11435# VCCD VCCD sky130_fd_pr__pfet_g5v0d10v5 ad=0.14 pd=1.28 as=0.14 ps=1.28 w=1 l=0.6
X31 a_1225_14186# a_689_12820# a_1072_14186# VSSA sky130_fd_pr__nfet_g5v0d10v5 ad=0.21 pd=1.78 as=0.3975 ps=3.53 w=1.5 l=0.5
X32 a_8699_10272# sky130_fd_io__gpiov2_amux_0/sky130_fd_io__gpiov2_amux_ctl_logic_0/sky130_fd_io__gpiov2_amux_decoder_0/sky130_fd_io__inv_1_9/A VSSD VSSD sky130_fd_pr__nfet_01v8_lvt ad=0.14 pd=1.28 as=0.265 ps=2.53 w=1 l=0.15
X33 a_11173_10272# VCCD a_10940_10272# VSSD sky130_fd_pr__nfet_05v0_nvt ad=0.14 pd=1.28 as=0.265 ps=2.53 w=1 l=0.9
X34 a_9067_10698# VCCD a_8699_10272# VSSD sky130_fd_pr__nfet_05v0_nvt ad=0.14 pd=1.28 as=0.265 ps=2.53 w=1 l=0.9
X35 a_2250_17651# a_7173_10183# VDDIO_Q VDDIO_Q sky130_fd_pr__pfet_g5v0d10v5 ad=0.14 pd=1.28 as=0.14 ps=1.28 w=1 l=0.6
X36 VSSIO_Q a_387_12076# sky130_fd_io__gpiov2_amux_0/sky130_fd_io__res75only_small_5/ROUT VSSIO_Q sky130_fd_pr__nfet_g5v0d10v5 ad=0.7 pd=5.28 as=0.7 ps=5.28 w=5 l=0.5
X37 a_3218_11709# ENABLE_VSWITCH_H VSSA VSSA sky130_fd_pr__nfet_g5v0d10v5 ad=0.795 pd=6.53 as=0.795 ps=6.53 w=3 l=0.5
X38 a_1077_11842# a_1024_11940# VSWITCH VSWITCH sky130_fd_pr__pfet_g5v0d10v5 ad=0.1113 pd=1.37 as=0.0588 ps=0.7 w=0.42 l=1
X39 VSSA VSSA a_387_12076# VSSA sky130_fd_pr__nfet_g5v0d10v5 ad=0.3975 pd=3.53 as=0.21 ps=1.78 w=1.5 l=0.5
X40 sky130_fd_io__gpiov2_amux_0/sky130_fd_io__amux_switch_1v2b_1/NG_PAD_VPMP_H a_1225_14186# VSSA VSSA sky130_fd_pr__nfet_g5v0d10v5 ad=0.0588 pd=0.7 as=0.0588 ps=0.7 w=0.42 l=0.6
X41 VSSD a_6895_11435# a_7015_11461# VSSD sky130_fd_pr__nfet_g5v0d10v5 ad=0.098 pd=0.98 as=0.098 ps=0.98 w=0.7 l=0.6
X42 VDDA ENABLE_VDDA_H a_195_17182# VDDA sky130_fd_pr__pfet_g5v0d10v5 ad=0.3975 pd=3.53 as=0.21 ps=1.78 w=1.5 l=0.5
X43 sky130_fd_io__gpiov2_amux_0/sky130_fd_io__gpiov2_amux_ctl_logic_0/sky130_fd_io__gpiov2_amux_decoder_0/sky130_fd_io__inv_1_7/A a_11131_11430# VCCD VCCD sky130_fd_pr__pfet_g5v0d10v5 ad=0.1113 pd=1.37 as=0.15455 ps=1.37 w=0.42 l=0.5
X44 a_643_12102# sky130_fd_io__gpiov2_amux_0/sky130_fd_io__amux_switch_1v2b_0/NG_PAD_VPMP_H VSWITCH VSWITCH sky130_fd_pr__pfet_g5v0d10v5 ad=0.3975 pd=3.53 as=0.21 ps=1.78 w=1.5 l=0.5
X45 a_8067_11435# a_8765_11461# VSSD VSSD sky130_fd_pr__nfet_g5v0d10v5 ad=0.098 pd=0.98 as=0.196 ps=1.96 w=0.7 l=0.6
X46 a_229_14828# a_282_14802# a_382_14828# VSSA sky130_fd_pr__nfet_g5v0d10v5 ad=0.42 pd=3.28 as=0.42 ps=3.28 w=3 l=0.5
X47 VSSD ANALOG_EN a_13816_1289# VSSD sky130_fd_pr__nfet_01v8 ad=0.2627 pd=2.19 as=0.2109 ps=2.05 w=0.74 l=0.15
R0 PAD PAD_A_NOESD_H sky130_fd_pr__res_generic_m3 w=1.07 l=0.035
X48 a_7367_11461# a_7015_11461# VCCD VCCD sky130_fd_pr__pfet_g5v0d10v5 ad=0.265 pd=2.53 as=0.14 ps=1.28 w=1 l=0.6
X49 w_9674_14653# sky130_fd_io__gpiov2_ctl_0/sky130_fd_io__com_ctl_hldv2_0/HLD_I_H VSSA VSSA sky130_fd_pr__nfet_g5v0d10v5 ad=0.1176 pd=1.4 as=0.1176 ps=1.4 w=0.42 l=0.5
X50 a_593_13760# VCCD a_1072_14186# VSSA sky130_fd_pr__nfet_05v0_nvt ad=0.14 pd=1.28 as=0.265 ps=2.53 w=1 l=0.9
X51 a_2982_13760# a_689_12820# a_2162_14426# VSSA sky130_fd_pr__nfet_g5v0d10v5 ad=0.21 pd=1.78 as=0.3975 ps=3.53 w=1.5 l=0.5
X52 a_6895_11435# a_7539_11435# VCCD VCCD sky130_fd_pr__pfet_g5v0d10v5 ad=0.14 pd=1.28 as=0.265 ps=2.53 w=1 l=0.6
X53 VSWITCH a_387_12076# a_334_12102# VSWITCH sky130_fd_pr__pfet_g5v0d10v5 ad=0.21 pd=1.78 as=0.3975 ps=3.53 w=1.5 l=0.5
X54 a_643_12102# sky130_fd_io__gpiov2_amux_0/sky130_fd_io__amux_switch_1v2b_0/NG_PAD_VPMP_H VSSA VSSA sky130_fd_pr__nfet_g5v0d10v5 ad=0.19875 pd=2.03 as=0.105 ps=1.03 w=0.75 l=0.5
X55 a_14092_2778# VCCD a_14053_2496# VSSD sky130_fd_pr__nfet_05v0_nvt ad=0.14 pd=1.28 as=0.265 ps=2.53 w=1 l=0.9
X56 a_7539_11435# sky130_fd_io__gpiov2_amux_0/sky130_fd_io__amux_switch_1v2b_0/NG_PAD_VPMP_H VSSD VSSD sky130_fd_pr__nfet_g5v0d10v5 ad=0.098 pd=0.98 as=0.1855 ps=1.93 w=0.7 l=0.6
X57 VSWITCH a_1225_12852# sky130_fd_io__gpiov2_amux_0/sky130_fd_io__amux_switch_1v2b_0/NG_PAD_VPMP_H VSWITCH sky130_fd_pr__pfet_g5v0d10v5 ad=0.265 pd=2.53 as=0.14 ps=1.28 w=1 l=0.6
X58 VSSA a_387_12076# a_334_12102# VSSA sky130_fd_pr__nfet_g5v0d10v5 ad=0.105 pd=1.03 as=0.19875 ps=2.03 w=0.75 l=0.5
X59 VSWITCH a_1024_12357# a_2162_14426# VSWITCH sky130_fd_pr__pfet_g5v0d10v5 ad=0.098 pd=0.98 as=0.1855 ps=1.93 w=0.7 l=0.6
X60 VSSIO_Q a_387_12076# sky130_fd_io__gpiov2_amux_0/sky130_fd_io__res75only_small_4/ROUT VSSIO_Q sky130_fd_pr__nfet_g5v0d10v5 ad=0.7 pd=5.28 as=0.7 ps=5.28 w=5 l=0.5
X61 VCCD sky130_fd_io__gpiov2_amux_0/sky130_fd_io__amux_switch_1v2b_1/PG_PAD_VDDIOQ_H_N a_8765_11461# VCCD sky130_fd_pr__pfet_g5v0d10v5 ad=0.265 pd=2.53 as=0.14 ps=1.28 w=1 l=0.6
X62 a_2749_13760# sky130_fd_io__gpiov2_amux_0/sky130_fd_io__gpiov2_amux_ctl_logic_0/sky130_fd_io__gpiov2_amux_decoder_0/sky130_fd_io__inv_1_0/Y VSSA VSSA sky130_fd_pr__nfet_01v8_lvt ad=0.14 pd=1.28 as=0.14 ps=1.28 w=1 l=0.15
X63 a_14397_2496# VCCD a_13902_2778# VSSD sky130_fd_pr__nfet_05v0_nvt ad=0.14 pd=1.28 as=0.14 ps=1.28 w=1 l=0.9
X64 VCCD a_10643_12610# sky130_fd_io__gpiov2_amux_0/sky130_fd_io__gpiov2_amux_ctl_logic_0/sky130_fd_io__gpiov2_amux_decoder_0/sky130_fd_io__inv_1_9/A VCCD sky130_fd_pr__pfet_g5v0d10v5 ad=0.15455 pd=1.37 as=0.1113 ps=1.37 w=0.42 l=0.5
X65 VSSA a_787_17182# a_2080_14827# VSSA sky130_fd_pr__nfet_g5v0d10v5 ad=0.795 pd=6.53 as=0.795 ps=6.53 w=3 l=0.5
X66 a_9350_10698# VCCD a_8871_10272# VSSD sky130_fd_pr__nfet_05v0_nvt ad=0.265 pd=2.53 as=0.14 ps=1.28 w=1 l=0.9
X67 a_6543_11435# sky130_fd_io__gpiov2_amux_0/sky130_fd_io__gpiov2_amux_ctl_logic_0/sky130_fd_io__gpiov2_amux_decoder_0/sky130_fd_io__inv_1_2/Y VCCD VCCD sky130_fd_pr__pfet_g5v0d10v5 ad=0.14 pd=1.28 as=0.14 ps=1.28 w=1 l=0.6
X68 a_13970_2496# a_13760_1103# a_14053_2496# VSSD sky130_fd_pr__nfet_01v8_lvt ad=0.14 pd=1.28 as=0.14 ps=1.28 w=1 l=0.15
X69 a_324_14186# a_377_12820# VSSA VSSA sky130_fd_pr__nfet_g5v0d10v5 ad=0.21 pd=1.78 as=0.21 ps=1.78 w=1.5 l=0.5
X70 VSSA a_377_12820# a_324_14186# VSSA sky130_fd_pr__nfet_g5v0d10v5 ad=0.21 pd=1.78 as=0.3975 ps=3.53 w=1.5 l=0.5
X71 a_2080_14827# a_1079_9778# a_184_17734# VSSA sky130_fd_pr__nfet_g5v0d10v5 ad=0.42 pd=3.28 as=0.42 ps=3.28 w=3 l=0.5
X72 VSSD a_7173_10183# a_2250_17651# VSSD sky130_fd_pr__nfet_g5v0d10v5 ad=0.0588 pd=0.7 as=0.0588 ps=0.7 w=0.42 l=0.6
X73 sky130_fd_io__gpiov2_amux_0/sky130_fd_io__amux_switch_1v2b_1/PG_AMX_VDDA_H_N a_184_18182# VSSA VSSA sky130_fd_pr__nfet_g5v0d10v5 ad=0.265 pd=2.53 as=0.14 ps=1.28 w=1 l=0.5
X74 VSSA a_195_17182# w_12765_16869# VSSA sky130_fd_pr__nfet_g5v0d10v5 ad=0.1176 pd=1.4 as=0.1176 ps=1.4 w=0.42 l=0.5
X75 a_1072_12852# a_689_12820# a_1225_12852# VSSA sky130_fd_pr__nfet_g5v0d10v5 ad=0.3975 pd=3.53 as=0.21 ps=1.78 w=1.5 l=0.5
X76 a_593_13760# sky130_fd_io__gpiov2_amux_0/sky130_fd_io__gpiov2_amux_ctl_logic_0/sky130_fd_io__gpiov2_amux_decoder_0/sky130_fd_io__inv_1_9/Y VSSA VSSA sky130_fd_pr__nfet_01v8_lvt ad=0.14 pd=1.28 as=0.14 ps=1.28 w=1 l=0.15
R1 PAD_A_NOESD_H PAD sky130_fd_pr__res_generic_m4 w=12.37 l=0.035
X77 VDDIO_Q a_2250_17651# sky130_fd_io__gpiov2_amux_0/sky130_fd_io__res75only_small_4/ROUT VDDIO_Q sky130_fd_pr__pfet_g5v0d10v5 ad=2.1 pd=15.28 as=2.1 ps=15.28 w=15 l=0.5
X78 a_2392_13760# sky130_fd_io__gpiov2_amux_0/sky130_fd_io__gpiov2_amux_ctl_logic_0/sky130_fd_io__gpiov2_amux_decoder_0/sky130_fd_io__inv_1_7/Y VSSA VSSA sky130_fd_pr__nfet_01v8_lvt ad=0.14 pd=1.28 as=0.265 ps=2.53 w=1 l=0.15
X79 a_178_9778# a_282_14802# a_643_9778# VSSD sky130_fd_pr__nfet_g5v0d10v5 ad=0.3975 pd=3.53 as=0.21 ps=1.78 w=1.5 l=0.5
X80 VCCD a_6367_11435# a_6314_11461# VCCD sky130_fd_pr__pfet_g5v0d10v5 ad=0.14 pd=1.28 as=0.265 ps=2.53 w=1 l=0.6
X81 VSSA sky130_fd_io__gpiov2_ctl_0/sky130_fd_io__com_ctl_hldv2_0/HLD_I_H w_9674_16869# VSSA sky130_fd_pr__nfet_g5v0d10v5 ad=0.1176 pd=1.4 as=0.1176 ps=1.4 w=0.42 l=0.5
X82 sky130_fd_io__gpiov2_amux_0/sky130_fd_io__amux_switch_1v2b_0/NG_PAD_VPMP_H a_231_9686# VSSA VSSA sky130_fd_pr__nfet_g5v0d10v5 ad=0.265 pd=2.53 as=0.14 ps=1.28 w=1 l=0.5
X83 a_178_9778# a_1079_9778# VDDIO_Q VDDIO_Q sky130_fd_pr__pfet_g5v0d10v5 ad=0.1855 pd=1.93 as=0.098 ps=0.98 w=0.7 l=0.6
X84 VSWITCH a_1077_11842# a_1024_11940# VSWITCH sky130_fd_pr__pfet_g5v0d10v5 ad=0.0588 pd=0.7 as=0.1113 ps=1.37 w=0.42 l=1
X85 a_2159_13760# VCCD a_2392_13760# VSSA sky130_fd_pr__nfet_05v0_nvt ad=0.265 pd=2.53 as=0.14 ps=1.28 w=1 l=0.9
X86 VCCD sky130_fd_io__gpiov2_amux_0/sky130_fd_io__gpiov2_amux_ctl_logic_0/sky130_fd_io__gpiov2_amux_decoder_0/sky130_fd_io__inv_1_7/A a_11131_11430# VCCD sky130_fd_pr__pfet_g5v0d10v5 ad=0.15455 pd=1.37 as=0.14 ps=1.28 w=1 l=0.6
X87 a_11523_13190# sky130_fd_io__gpiov2_amux_0/sky130_fd_io__gpiov2_amux_ctl_logic_0/sky130_fd_io__gpiov2_amux_decoder_0/sky130_fd_io__inv_1_8/A VCCD VCCD sky130_fd_pr__pfet_g5v0d10v5 ad=0.14 pd=1.28 as=0.14 ps=1.28 w=1 l=0.6
X88 sky130_fd_io__gpiov2_amux_0/sky130_fd_io__amux_switch_1v2b_1/NG_AMX_VPMP_H a_1225_14186# VSSA VSSA sky130_fd_pr__nfet_g5v0d10v5 ad=0.0588 pd=0.7 as=0.0588 ps=0.7 w=0.42 l=0.6
X89 VSSA a_231_9686# sky130_fd_io__gpiov2_amux_0/sky130_fd_io__amux_switch_1v2b_1/NG_PAD_VPMP_H VSSA sky130_fd_pr__nfet_g5v0d10v5 ad=0.14 pd=1.28 as=0.265 ps=2.53 w=1 l=0.5
X90 a_787_17182# a_229_14828# VDDA VDDA sky130_fd_pr__pfet_g5v0d10v5 ad=0.3975 pd=3.53 as=0.21 ps=1.78 w=1.5 l=0.5
X91 VSSD a_10643_12610# VSSD VSSD sky130_fd_pr__nfet_g5v0d10v5 ad=0.47105 pd=3.65 as=0 ps=0 w=0.42 l=0.5
X92 a_7659_11461# a_7539_11435# a_6895_11435# VSSD sky130_fd_pr__nfet_g5v0d10v5 ad=0.098 pd=0.98 as=0.1855 ps=1.93 w=0.7 l=0.6
X93 VCCD sky130_fd_io__gpiov2_amux_0/sky130_fd_io__gpiov2_amux_ctl_logic_0/sky130_fd_io__gpiov2_amux_decoder_0/sky130_fd_io__nor2_1_3/Y sky130_fd_io__gpiov2_amux_0/sky130_fd_io__gpiov2_amux_ctl_logic_0/sky130_fd_io__gpiov2_amux_decoder_0/sky130_fd_io__inv_1_7/A VCCD sky130_fd_pr__pfet_g5v0d10v5 ad=0.14 pd=1.28 as=0.14 ps=1.28 w=1 l=0.6
X94 VSSD a_3642_14801# sky130_fd_io__gpiov2_amux_0/sky130_fd_io__amux_switch_1v2b_1/PG_PAD_VDDIOQ_H_N VSSD sky130_fd_pr__nfet_g5v0d10v5 ad=0.0588 pd=0.7 as=0.0588 ps=0.7 w=0.42 l=0.6
X95 a_2250_17651# a_7173_10183# VDDIO_Q VDDIO_Q sky130_fd_pr__pfet_g5v0d10v5 ad=0.14 pd=1.28 as=0.14 ps=1.28 w=1 l=0.6
X96 a_421_13760# sky130_fd_io__gpiov2_amux_0/sky130_fd_io__gpiov2_amux_ctl_logic_0/sky130_fd_io__gpiov2_amux_decoder_0/sky130_fd_io__inv_1_9/A VSSA VSSA sky130_fd_pr__nfet_01v8_lvt ad=0.14 pd=1.28 as=0.265 ps=2.53 w=1 l=0.15
X97 VCCD ANALOG_EN a_13816_1289# VCCD sky130_fd_pr__pfet_01v8_hvt ad=0.345 pd=2.69 as=0.295 ps=2.59 w=1 l=0.25
X98 VSSA a_195_17182# w_9674_14653# VSSA sky130_fd_pr__nfet_g5v0d10v5 ad=0.1176 pd=1.4 as=0.1176 ps=1.4 w=0.42 l=0.5
X99 a_789_12852# VCCD a_421_13378# VSSA sky130_fd_pr__nfet_05v0_nvt ad=0.14 pd=1.28 as=0.265 ps=2.53 w=1 l=0.9
X100 VDDA a_620_18182# a_184_18182# VDDA sky130_fd_pr__pfet_g5v0d10v5 ad=0.0588 pd=0.7 as=0.1113 ps=1.37 w=0.42 l=1
X101 a_689_12820# a_1024_11940# VSWITCH VSWITCH sky130_fd_pr__pfet_g5v0d10v5 ad=0.3975 pd=3.53 as=0.21 ps=1.78 w=1.5 l=0.5
X102 VSSA sky130_fd_io__gpiov2_ctl_0/sky130_fd_io__com_ctl_hldv2_0/HLD_I_H w_12765_14755# VSSA sky130_fd_pr__nfet_g5v0d10v5 ad=0.1176 pd=1.4 as=0.1176 ps=1.4 w=0.42 l=0.5
X103 sky130_fd_io__gpiov2_amux_0/sky130_fd_io__amux_switch_1v2b_0/PG_PAD_VDDIOQ_H_N a_178_9778# VDDIO_Q VDDIO_Q sky130_fd_pr__pfet_g5v0d10v5 ad=0.14 pd=1.28 as=0.265 ps=2.53 w=1 l=0.6
X104 sky130_fd_io__gpiov2_amux_0/sky130_fd_io__amux_switch_1v2b_1/PG_PAD_VDDIOQ_H_N a_3642_14801# VDDIO_Q VDDIO_Q sky130_fd_pr__pfet_g5v0d10v5 ad=0.14 pd=1.28 as=0.14 ps=1.28 w=1 l=0.6
X105 sky130_fd_io__gpiov2_amux_0/sky130_fd_io__gpiov2_amux_ctl_logic_0/sky130_fd_io__gpiov2_amux_decoder_0/sky130_fd_io__inv_1_7/A sky130_fd_io__gpiov2_amux_0/sky130_fd_io__amux_switch_1v2b_0/PG_PAD_VDDIOQ_H_N a_10705_12172# VSSD sky130_fd_pr__nfet_g5v0d10v5 ad=1.325 pd=10.53 as=0.7 ps=5.28 w=5 l=0.5
X106 a_14397_2496# a_13816_1289# a_13970_2496# VSSD sky130_fd_pr__nfet_01v8_lvt ad=0.14 pd=1.28 as=0.14 ps=1.28 w=1 l=0.15
X107 a_10643_12610# sky130_fd_io__gpiov2_amux_0/sky130_fd_io__gpiov2_amux_ctl_logic_0/sky130_fd_io__gpiov2_amux_decoder_0/sky130_fd_io__inv_1_9/A VSSD VSSD sky130_fd_pr__nfet_g5v0d10v5 ad=0.1113 pd=1.37 as=0.47105 ps=3.65 w=0.42 l=0.5
X108 VSSD sky130_fd_io__gpiov2_amux_0/sky130_fd_io__gpiov2_amux_ctl_logic_0/sky130_fd_io__gpiov2_amux_decoder_0/sky130_fd_io__inv_1_1/Y a_10940_10272# VSSD sky130_fd_pr__nfet_01v8_lvt ad=0.265 pd=2.53 as=0.14 ps=1.28 w=1 l=0.15
X109 VSSD sky130_fd_io__gpiov2_amux_0/sky130_fd_io__gpiov2_amux_ctl_logic_0/sky130_fd_io__gpiov2_amux_decoder_0/sky130_fd_io__inv_1_11/Y a_7370_13247# VSSD sky130_fd_pr__nfet_01v8 ad=0.1176 pd=1.12 as=0.1176 ps=1.12 w=0.84 l=0.15
X110 a_14053_2496# VCCD a_14092_2778# VSSD sky130_fd_pr__nfet_05v0_nvt ad=0.14 pd=1.28 as=0.14 ps=1.28 w=1 l=0.9
X111 sky130_fd_io__gpiov2_amux_0/sky130_fd_io__gpiov2_amux_ctl_logic_0/sky130_fd_io__gpiov2_amux_decoder_0/sky130_fd_io__inv_1_9/A sky130_fd_io__gpiov2_amux_0/sky130_fd_io__gpiov2_amux_ctl_logic_0/sky130_fd_io__gpiov2_amux_decoder_0/sky130_fd_io__inv_1_2/A VCCD VCCD sky130_fd_pr__pfet_g5v0d10v5 ad=0.14 pd=1.28 as=0.14 ps=1.28 w=1 l=0.6
X112 sky130_fd_io__gpiov2_amux_0/sky130_fd_io__gpiov2_amux_ctl_logic_0/sky130_fd_io__gpiov2_amux_decoder_0/sky130_fd_io__inv_1_8/A sky130_fd_io__gpiov2_amux_0/sky130_fd_io__gpiov2_amux_ctl_logic_0/sky130_fd_io__gpiov2_amux_decoder_0/sky130_fd_io__nor2_1_2/Y VCCD VCCD sky130_fd_pr__pfet_g5v0d10v5 ad=0.14 pd=1.28 as=0.14 ps=1.28 w=1 l=0.6
X113 sky130_fd_io__gpiov2_amux_0/sky130_fd_io__gpiov2_amux_ctl_logic_0/sky130_fd_io__gpiov2_amux_decoder_0/sky130_fd_io__nand2_1_1/B sky130_fd_io__gpiov2_amux_0/sky130_fd_io__gpiov2_amux_ctl_logic_0/sky130_fd_io__gpiov2_amux_decoder_0/sky130_fd_io__inv_1_3/Y a_7625_13629# VSSD sky130_fd_pr__nfet_01v8 ad=0.2436 pd=1.42 as=0.1008 ps=1.08 w=0.84 l=0.15
X114 VSSD a_6367_11435# a_6314_11461# VSSD sky130_fd_pr__nfet_g5v0d10v5 ad=0.098 pd=0.98 as=0.1855 ps=1.93 w=0.7 l=0.6
R2 PAD_A_NOESD_H PAD sky130_fd_pr__res_generic_m3 w=12.37 l=0.035
X115 a_1024_12357# a_2162_14426# VSWITCH VSWITCH sky130_fd_pr__pfet_g5v0d10v5 ad=0.1855 pd=1.93 as=0.098 ps=0.98 w=0.7 l=0.6
X116 a_7621_13247# sky130_fd_io__gpiov2_amux_0/sky130_fd_io__gpiov2_amux_ctl_logic_0/sky130_fd_io__gpiov2_amux_decoder_0/sky130_fd_io__inv_1_11/Y VCCD VCCD sky130_fd_pr__pfet_01v8_hvt ad=0.1764 pd=1.54 as=0.189 ps=1.56 w=1.26 l=0.15
X117 a_7625_13629# sky130_fd_io__gpiov2_amux_0/sky130_fd_io__gpiov2_amux_ctl_logic_0/sky130_fd_io__gpiov2_amux_decoder_0/sky130_fd_io__inv_1_11/Y VSSD VSSD sky130_fd_pr__nfet_01v8 ad=0.1008 pd=1.08 as=0.1176 ps=1.12 w=0.84 l=0.15
X118 a_12162_13064# a_334_12102# a_12006_13064# VSSD sky130_fd_pr__nfet_g5v0d10v5 ad=0.7 pd=5.28 as=0.7 ps=5.28 w=5 l=0.5
X119 a_324_14186# a_1225_14186# VSWITCH VSWITCH sky130_fd_pr__pfet_g5v0d10v5 ad=0.1855 pd=1.93 as=0.098 ps=0.98 w=0.7 l=0.6
X120 VDDA a_497_17084# a_478_17182# VDDA sky130_fd_pr__pfet_g5v0d10v5 ad=0.21 pd=1.78 as=0.3975 ps=3.53 w=1.5 l=0.5
X121 VSSD a_178_9778# sky130_fd_io__gpiov2_amux_0/sky130_fd_io__amux_switch_1v2b_0/PG_PAD_VDDIOQ_H_N VSSD sky130_fd_pr__nfet_g5v0d10v5 ad=0.0588 pd=0.7 as=0.0588 ps=0.7 w=0.42 l=0.6
X122 a_2250_17651# a_7173_10183# VDDIO_Q VDDIO_Q sky130_fd_pr__pfet_g5v0d10v5 ad=0.14 pd=1.28 as=0.14 ps=1.28 w=1 l=0.6
X123 a_7621_13247# a_7370_13247# sky130_fd_io__gpiov2_amux_0/sky130_fd_io__gpiov2_amux_ctl_logic_0/sky130_fd_io__gpiov2_amux_decoder_0/sky130_fd_io__nand2_1_1/B VCCD sky130_fd_pr__pfet_01v8_hvt ad=0.3339 pd=3.05 as=0.3591 ps=3.09 w=1.26 l=0.15
X124 a_10705_12172# sky130_fd_io__gpiov2_amux_0/sky130_fd_io__amux_switch_1v2b_1/PG_PAD_VDDIOQ_H_N a_10705_12016# VSSD sky130_fd_pr__nfet_g5v0d10v5 ad=0.7 pd=5.28 as=0.7 ps=5.28 w=5 l=0.5
X125 sky130_fd_io__gpiov2_amux_0/sky130_fd_io__amux_switch_1v2b_0/NG_AMX_VPMP_H a_1225_12852# VSWITCH VSWITCH sky130_fd_pr__pfet_g5v0d10v5 ad=0.14 pd=1.28 as=0.265 ps=2.53 w=1 l=0.6
X126 sky130_fd_io__gpiov2_amux_0/sky130_fd_io__res75only_small_5/ROUT a_387_12076# VSSIO_Q VSSIO_Q sky130_fd_pr__nfet_g5v0d10v5 ad=0.7 pd=5.28 as=0.7 ps=5.28 w=5 l=0.5
X127 sky130_fd_io__gpiov2_amux_0/sky130_fd_io__res75only_small_5/ROUT a_387_12076# VSSIO_Q VSSIO_Q sky130_fd_pr__nfet_g5v0d10v5 ad=0.7 pd=5.28 as=0.7 ps=5.28 w=5 l=0.5
X128 a_14053_2496# a_13760_1103# a_13970_2496# VSSD sky130_fd_pr__nfet_01v8_lvt ad=0.14 pd=1.28 as=0.265 ps=2.53 w=1 l=0.15
X129 a_10705_11704# sky130_fd_io__gpiov2_amux_0/sky130_fd_io__gpiov2_amux_ctl_logic_0/sky130_fd_io__gpiov2_amux_decoder_0/sky130_fd_io__nor2_1_3/Y VSSD VSSD sky130_fd_pr__nfet_g5v0d10v5 ad=0.7 pd=5.28 as=0.47105 ps=3.65 w=5 l=0.5
X130 VSSD a_11131_11430# VSSD VSSD sky130_fd_pr__nfet_g5v0d10v5 ad=0.47105 pd=3.65 as=0 ps=0 w=0.42 l=0.5
X131 VCCD sky130_fd_io__gpiov2_amux_0/sky130_fd_io__amux_switch_1v2b_0/PG_PAD_VDDIOQ_H_N a_8300_11461# VCCD sky130_fd_pr__pfet_g5v0d10v5 ad=0.265 pd=2.53 as=0.14 ps=1.28 w=1 l=0.6
X132 VSSA ENABLE_VSWITCH_H a_342_11805# VSSA sky130_fd_pr__nfet_g5v0d10v5 ad=0.1855 pd=1.93 as=0.1855 ps=1.93 w=0.7 l=0.6
X133 a_421_13378# VCCD a_789_12852# VSSA sky130_fd_pr__nfet_05v0_nvt ad=0.265 pd=2.53 as=0.14 ps=1.28 w=1 l=0.9
X134 VSSD sky130_fd_io__gpiov2_amux_0/sky130_fd_io__gpiov2_amux_ctl_logic_0/sky130_fd_io__gpiov2_amux_decoder_0/sky130_fd_io__inv_1_5/A a_12443_12112# VSSD sky130_fd_pr__nfet_g5v0d10v5 ad=0.47105 pd=3.65 as=0.1113 ps=1.37 w=0.42 l=0.5
X135 sky130_fd_io__gpiov2_amux_0/sky130_fd_io__gpiov2_amux_ctl_logic_0/sky130_fd_io__gpiov2_amux_decoder_0/sky130_fd_io__inv_1_5/A sky130_fd_io__gpiov2_amux_0/sky130_fd_io__amux_switch_1v2b_0/PG_PAD_VDDIOQ_H_N a_12897_12172# VSSD sky130_fd_pr__nfet_g5v0d10v5 ad=1.325 pd=10.53 as=0.7 ps=5.28 w=5 l=0.5
X136 VSSD sky130_fd_io__gpiov2_amux_0/sky130_fd_io__gpiov2_amux_ctl_logic_0/sky130_fd_io__gpiov2_amux_decoder_0/sky130_fd_io__inv_1_9/Y a_8871_10272# VSSD sky130_fd_pr__nfet_01v8_lvt ad=0.265 pd=2.53 as=0.14 ps=1.28 w=1 l=0.15
X137 a_13970_2496# a_13816_1289# a_14397_2496# VSSD sky130_fd_pr__nfet_01v8_lvt ad=0.265 pd=2.53 as=0.14 ps=1.28 w=1 l=0.15
X138 VCCD a_6895_11435# a_7015_11461# VCCD sky130_fd_pr__pfet_g5v0d10v5 ad=0.14 pd=1.28 as=0.14 ps=1.28 w=1 l=0.6
X139 a_8699_10272# VCCD a_9067_10698# VSSD sky130_fd_pr__nfet_05v0_nvt ad=0.265 pd=2.53 as=0.14 ps=1.28 w=1 l=0.9
X140 a_620_17850# a_184_17734# VDDA VDDA sky130_fd_pr__pfet_g5v0d10v5 ad=0.1113 pd=1.37 as=0.0588 ps=0.7 w=0.42 l=1
X141 VSSD a_7173_10183# a_2250_17651# VSSD sky130_fd_pr__nfet_g5v0d10v5 ad=0.0588 pd=0.7 as=0.0588 ps=0.7 w=0.42 l=0.6
X142 a_9877_11799# a_8765_11461# a_8067_11435# VCCD sky130_fd_pr__pfet_g5v0d10v5 ad=0.14 pd=1.28 as=0.265 ps=2.53 w=1 l=0.6
X143 VSSD a_7173_10183# a_2250_17651# VSSD sky130_fd_pr__nfet_g5v0d10v5 ad=0.0588 pd=0.7 as=0.0588 ps=0.7 w=0.42 l=0.6
X144 a_2250_17651# a_7173_10183# VDDIO_Q VDDIO_Q sky130_fd_pr__pfet_g5v0d10v5 ad=0.265 pd=2.53 as=0.14 ps=1.28 w=1 l=0.6
X145 sky130_fd_io__gpiov2_amux_0/sky130_fd_io__res75only_small_4/ROUT a_2250_17651# VDDIO_Q VDDIO_Q sky130_fd_pr__pfet_g5v0d10v5 ad=4.2 pd=30.56 as=2.1 ps=15.28 w=15 l=0.5
X146 sky130_fd_io__gpiov2_amux_0/sky130_fd_io__amux_switch_1v2b_0/NG_PAD_VPMP_H a_1225_12852# VSWITCH VSWITCH sky130_fd_pr__pfet_g5v0d10v5 ad=0.14 pd=1.28 as=0.14 ps=1.28 w=1 l=0.6
X147 a_14397_2496# a_13816_1289# a_13970_2496# VSSD sky130_fd_pr__nfet_01v8_lvt ad=0.14 pd=1.28 as=0.14 ps=1.28 w=1 l=0.15
X148 VSSD sky130_fd_io__gpiov2_ctl_0/HLD_I_H_N a_13970_2496# VSSD sky130_fd_pr__nfet_g5v0d10v5 ad=0.14 pd=1.28 as=0.14 ps=1.28 w=1 l=0.5
X149 sky130_fd_io__gpiov2_amux_0/sky130_fd_io__res75only_small_4/ROUT a_387_12076# VSSIO_Q VSSIO_Q sky130_fd_pr__nfet_g5v0d10v5 ad=0.7 pd=5.28 as=0.7 ps=5.28 w=5 l=0.5
X150 a_497_17084# a_195_17182# VSSA VSSA sky130_fd_pr__nfet_g5v0d10v5 ad=0.265 pd=2.53 as=0.265 ps=2.53 w=1 l=0.5
X151 a_2080_14827# a_178_9778# a_620_17850# VSSA sky130_fd_pr__nfet_g5v0d10v5 ad=0.42 pd=3.28 as=0.42 ps=3.28 w=3 l=0.5
X152 VSSIO_Q a_387_12076# sky130_fd_io__gpiov2_amux_0/sky130_fd_io__res75only_small_4/ROUT VSSIO_Q sky130_fd_pr__nfet_g5v0d10v5 ad=0.7 pd=5.28 as=0.7 ps=5.28 w=5 l=0.5
X153 a_447_9352# sky130_fd_io__gpiov2_amux_0/sky130_fd_io__gpiov2_amux_ctl_logic_0/sky130_fd_io__gpiov2_amux_decoder_0/sky130_fd_io__inv_1_8/Y VSSD VSSD sky130_fd_pr__nfet_01v8_lvt ad=0.14 pd=1.28 as=0.14 ps=1.28 w=1 l=0.15
X154 a_2080_14827# a_1079_9778# a_184_17734# VSSA sky130_fd_pr__nfet_g5v0d10v5 ad=0.42 pd=3.28 as=0.795 ps=6.53 w=3 l=0.5
X155 a_7173_10183# a_231_9686# VSSD VSSD sky130_fd_pr__nfet_g5v0d10v5 ad=0.3975 pd=3.53 as=0.21 ps=1.78 w=1.5 l=0.5
X156 a_9406_11799# sky130_fd_io__gpiov2_amux_0/sky130_fd_io__amux_switch_1v2b_0/NG_PAD_VPMP_H VCCD VCCD sky130_fd_pr__pfet_g5v0d10v5 ad=0.14 pd=1.28 as=0.265 ps=2.53 w=1 l=0.6
X157 a_12897_12172# sky130_fd_io__gpiov2_amux_0/sky130_fd_io__amux_switch_1v2b_1/PG_PAD_VDDIOQ_H_N a_12897_12016# VSSD sky130_fd_pr__nfet_g5v0d10v5 ad=0.7 pd=5.28 as=0.7 ps=5.28 w=5 l=0.5
X158 a_620_17850# a_178_9778# a_2080_14827# VSSA sky130_fd_pr__nfet_g5v0d10v5 ad=0.42 pd=3.28 as=0.42 ps=3.28 w=3 l=0.5
X159 a_1072_14186# VCCD a_593_13760# VSSA sky130_fd_pr__nfet_05v0_nvt ad=0.265 pd=2.53 as=0.14 ps=1.28 w=1 l=0.9
X160 sky130_fd_io__gpiov2_amux_0/sky130_fd_io__gpiov2_amux_ctl_logic_0/sky130_fd_io__gpiov2_amux_decoder_0/sky130_fd_io__inv_1_5/A a_12443_12112# VCCD VCCD sky130_fd_pr__pfet_g5v0d10v5 ad=0.1113 pd=1.37 as=0.15455 ps=1.37 w=0.42 l=0.5
X161 VSSD sky130_fd_io__gpiov2_amux_0/sky130_fd_io__gpiov2_amux_ctl_logic_0/sky130_fd_io__gpiov2_amux_decoder_0/sky130_fd_io__inv_1_9/A a_8699_10272# VSSD sky130_fd_pr__nfet_01v8_lvt ad=0.14 pd=1.28 as=0.14 ps=1.28 w=1 l=0.15
X162 VDDIO_Q a_3642_14801# a_4110_14801# VDDIO_Q sky130_fd_pr__pfet_g5v0d10v5 ad=0.098 pd=0.98 as=0.1855 ps=1.93 w=0.7 l=0.6
X163 a_12897_11704# sky130_fd_io__gpiov2_amux_0/sky130_fd_io__gpiov2_amux_ctl_logic_0/sky130_fd_io__gpiov2_amux_decoder_0/sky130_fd_io__nor2_1_1/Y VSSD VSSD sky130_fd_pr__nfet_g5v0d10v5 ad=0.7 pd=5.28 as=0.47105 ps=3.65 w=5 l=0.5
X164 VCCD a_8067_11435# a_6543_11435# VCCD sky130_fd_pr__pfet_g5v0d10v5 ad=0.265 pd=2.53 as=0.14 ps=1.28 w=1 l=0.6
X165 VSSA sky130_fd_io__gpiov2_amux_0/sky130_fd_io__gpiov2_amux_ctl_logic_0/sky130_fd_io__gpiov2_amux_decoder_0/sky130_fd_io__inv_1_8/Y a_593_13378# VSSA sky130_fd_pr__nfet_01v8_lvt ad=0.265 pd=2.53 as=0.14 ps=1.28 w=1 l=0.15
X166 sky130_fd_io__gpiov2_amux_0/sky130_fd_io__res75only_small_5/ROUT a_2250_17651# VDDIO_Q VDDIO_Q sky130_fd_pr__pfet_g5v0d10v5 ad=2.1 pd=15.28 as=2.1 ps=15.28 w=15 l=0.5
X167 a_447_9352# VCCD a_926_9778# VSSD sky130_fd_pr__nfet_05v0_nvt ad=0.14 pd=1.28 as=0.265 ps=2.53 w=1 l=0.9
X168 a_497_17084# a_231_9686# a_382_14828# VSSA sky130_fd_pr__nfet_g5v0d10v5 ad=0.795 pd=6.53 as=0.42 ps=3.28 w=3 l=0.5
X169 VSSD sky130_fd_io__gpiov2_amux_0/sky130_fd_io__amux_switch_1v2b_0/PG_PAD_VDDIOQ_H_N a_8473_11461# VSSD sky130_fd_pr__nfet_g5v0d10v5 ad=0.1855 pd=1.93 as=0.098 ps=0.98 w=0.7 l=0.6
X170 VDDIO_Q a_2250_17651# sky130_fd_io__gpiov2_amux_0/sky130_fd_io__res75only_small_5/ROUT VDDIO_Q sky130_fd_pr__pfet_g5v0d10v5 ad=2.1 pd=15.28 as=2.1 ps=15.28 w=15 l=0.5
X171 VCCD a_6543_11435# a_6367_11435# VCCD sky130_fd_pr__pfet_g5v0d10v5 ad=0.14 pd=1.28 as=0.14 ps=1.28 w=1 l=0.6
X172 w_9674_16869# a_195_17182# VSSA VSSA sky130_fd_pr__nfet_g5v0d10v5 ad=0.1176 pd=1.4 as=0.1176 ps=1.4 w=0.42 l=0.5
X173 a_3642_14801# a_282_14802# a_9067_10698# VSSD sky130_fd_pr__nfet_g5v0d10v5 ad=0.3975 pd=3.53 as=0.21 ps=1.78 w=1.5 l=0.5
X174 VSSA a_1225_12852# sky130_fd_io__gpiov2_amux_0/sky130_fd_io__amux_switch_1v2b_0/NG_AMX_VPMP_H VSSA sky130_fd_pr__nfet_g5v0d10v5 ad=0.0588 pd=0.7 as=0.0588 ps=0.7 w=0.42 l=0.6
X175 sky130_fd_io__gpiov2_amux_0/sky130_fd_io__gpiov2_amux_ctl_logic_0/sky130_fd_io__gpiov2_amux_decoder_0/sky130_fd_io__inv_1_8/A a_11523_13190# VCCD VCCD sky130_fd_pr__pfet_g5v0d10v5 ad=0.1113 pd=1.37 as=0.15455 ps=1.37 w=0.42 l=0.5
X176 a_13970_2496# a_13816_1289# a_14397_2496# VSSD sky130_fd_pr__nfet_01v8_lvt ad=0.14 pd=1.28 as=0.14 ps=1.28 w=1 l=0.15
X177 a_643_9778# a_282_14802# a_178_9778# VSSD sky130_fd_pr__nfet_g5v0d10v5 ad=0.21 pd=1.78 as=0.21 ps=1.78 w=1.5 l=0.5
X178 sky130_fd_io__gpiov2_amux_0/sky130_fd_io__amux_switch_1v2b_1/NG_PAD_VPMP_H a_1225_14186# VSWITCH VSWITCH sky130_fd_pr__pfet_g5v0d10v5 ad=0.14 pd=1.28 as=0.14 ps=1.28 w=1 l=0.6
X179 VSSD sky130_fd_io__gpiov2_amux_0/sky130_fd_io__gpiov2_amux_ctl_logic_0/sky130_fd_io__gpiov2_amux_decoder_0/sky130_fd_io__inv_1_8/Y a_447_9352# VSSD sky130_fd_pr__nfet_01v8_lvt ad=0.265 pd=2.53 as=0.14 ps=1.28 w=1 l=0.15
X180 a_13902_2778# VCCD a_14397_2496# VSSD sky130_fd_pr__nfet_05v0_nvt ad=0.14 pd=1.28 as=0.14 ps=1.28 w=1 l=0.9
X181 VSSA sky130_fd_io__gpiov2_amux_0/sky130_fd_io__gpiov2_amux_ctl_logic_0/sky130_fd_io__gpiov2_amux_decoder_0/sky130_fd_io__inv_1_8/A a_421_13378# VSSA sky130_fd_pr__nfet_01v8_lvt ad=0.14 pd=1.28 as=0.14 ps=1.28 w=1 l=0.15
X182 a_195_17182# ENABLE_VDDA_H VDDA VDDA sky130_fd_pr__pfet_g5v0d10v5 ad=0.21 pd=1.78 as=0.3975 ps=3.53 w=1.5 l=0.5
X183 a_14053_2496# a_13760_1103# a_13970_2496# VSSD sky130_fd_pr__nfet_01v8_lvt ad=0.14 pd=1.28 as=0.14 ps=1.28 w=1 l=0.15
X184 a_6895_11435# a_7539_11435# VCCD VCCD sky130_fd_pr__pfet_g5v0d10v5 ad=0.14 pd=1.28 as=0.265 ps=2.53 w=1 l=0.6
X185 VCCD sky130_fd_io__gpiov2_amux_0/sky130_fd_io__gpiov2_amux_ctl_logic_0/sky130_fd_io__gpiov2_amux_decoder_0/sky130_fd_io__inv_1_11/Y a_7453_13247# VCCD sky130_fd_pr__pfet_01v8_hvt ad=0.189 pd=1.56 as=0.1512 ps=1.5 w=1.26 l=0.15
X186 VSSA sky130_fd_io__gpiov2_amux_0/sky130_fd_io__gpiov2_amux_ctl_logic_0/sky130_fd_io__gpiov2_amux_decoder_0/sky130_fd_io__inv_1_0/Y a_2749_13760# VSSA sky130_fd_pr__nfet_01v8_lvt ad=0.265 pd=2.53 as=0.14 ps=1.28 w=1 l=0.15
X187 a_10643_12610# sky130_fd_io__gpiov2_amux_0/sky130_fd_io__gpiov2_amux_ctl_logic_0/sky130_fd_io__gpiov2_amux_decoder_0/sky130_fd_io__inv_1_9/A VCCD VCCD sky130_fd_pr__pfet_g5v0d10v5 ad=0.14 pd=1.28 as=0.15455 ps=1.37 w=1 l=0.6
X188 a_275_9352# sky130_fd_io__gpiov2_amux_0/sky130_fd_io__gpiov2_amux_ctl_logic_0/sky130_fd_io__gpiov2_amux_decoder_0/sky130_fd_io__inv_1_8/A VSSD VSSD sky130_fd_pr__nfet_01v8_lvt ad=0.14 pd=1.28 as=0.265 ps=2.53 w=1 l=0.15
X189 a_7453_13247# sky130_fd_io__gpiov2_amux_0/sky130_fd_io__gpiov2_amux_ctl_logic_0/sky130_fd_io__gpiov2_amux_decoder_0/sky130_fd_io__inv_1_3/Y a_7370_13247# VCCD sky130_fd_pr__pfet_01v8_hvt ad=0.1512 pd=1.5 as=0.3339 ps=3.05 w=1.26 l=0.15
X190 VCCD sky130_fd_io__gpiov2_amux_0/sky130_fd_io__amux_switch_1v2b_1/NG_PAD_VPMP_H a_9877_11799# VCCD sky130_fd_pr__pfet_g5v0d10v5 ad=0.265 pd=2.53 as=0.14 ps=1.28 w=1 l=0.6
X191 VSSA a_1225_14186# sky130_fd_io__gpiov2_amux_0/sky130_fd_io__amux_switch_1v2b_1/NG_PAD_VPMP_H VSSA sky130_fd_pr__nfet_g5v0d10v5 ad=0.0588 pd=0.7 as=0.0588 ps=0.7 w=0.42 l=0.6
X192 a_7173_10183# a_282_14802# a_11173_10272# VSSD sky130_fd_pr__nfet_g5v0d10v5 ad=0.21 pd=1.78 as=0.21 ps=1.78 w=1.5 l=0.5
X193 w_12765_14755# a_195_17182# VSSA VSSA sky130_fd_pr__nfet_g5v0d10v5 ad=0.1176 pd=1.4 as=0.1176 ps=1.4 w=0.42 l=0.5
X194 a_324_12852# a_689_12820# a_789_12852# VSSA sky130_fd_pr__nfet_g5v0d10v5 ad=0.3975 pd=3.53 as=0.21 ps=1.78 w=1.5 l=0.5
X195 a_787_17182# a_229_14828# VSSA VSSA sky130_fd_pr__nfet_g5v0d10v5 ad=0.265 pd=2.53 as=0.14 ps=1.28 w=1 l=0.5
X196 a_184_17734# a_1079_9778# a_2080_14827# VSSA sky130_fd_pr__nfet_g5v0d10v5 ad=0.42 pd=3.28 as=0.42 ps=3.28 w=3 l=0.5
X197 a_6543_11435# a_8067_11435# a_8011_11461# VSSD sky130_fd_pr__nfet_g5v0d10v5 ad=0.1855 pd=1.93 as=0.098 ps=0.98 w=0.7 l=0.6
X198 a_387_12076# a_1024_12357# VSWITCH VSWITCH sky130_fd_pr__pfet_g5v0d10v5 ad=0.105 pd=1.03 as=0.19875 ps=2.03 w=0.75 l=2
X199 a_11173_10272# a_282_14802# a_7173_10183# VSSD sky130_fd_pr__nfet_g5v0d10v5 ad=0.21 pd=1.78 as=0.3975 ps=3.53 w=1.5 l=0.5
X200 VSSIO_Q a_387_12076# sky130_fd_io__gpiov2_amux_0/sky130_fd_io__res75only_small_5/ROUT VSSIO_Q sky130_fd_pr__nfet_g5v0d10v5 ad=0.7 pd=5.28 as=0.7 ps=5.28 w=5 l=0.5
X201 a_10406_10767# a_282_14802# a_10350_10272# VSSD sky130_fd_pr__nfet_g5v0d10v5 ad=0.21 pd=1.78 as=0.3975 ps=3.53 w=1.5 l=0.5
X202 a_789_12852# a_689_12820# a_324_12852# VSSA sky130_fd_pr__nfet_g5v0d10v5 ad=0.21 pd=1.78 as=0.21 ps=1.78 w=1.5 l=0.5
X203 VSSA a_497_17084# a_478_17182# VSSA sky130_fd_pr__nfet_g5v0d10v5 ad=0.14 pd=1.28 as=0.265 ps=2.53 w=1 l=0.5
X204 a_926_9778# VCCD a_447_9352# VSSD sky130_fd_pr__nfet_05v0_nvt ad=0.265 pd=2.53 as=0.14 ps=1.28 w=1 l=0.9
X205 a_7539_11435# a_8300_11461# a_9406_11799# VCCD sky130_fd_pr__pfet_g5v0d10v5 ad=0.265 pd=2.53 as=0.14 ps=1.28 w=1 l=0.6
X206 a_11850_13064# sky130_fd_io__gpiov2_amux_0/sky130_fd_io__gpiov2_amux_ctl_logic_0/sky130_fd_io__gpiov2_amux_decoder_0/sky130_fd_io__nor2_1_2/Y VSSD VSSD sky130_fd_pr__nfet_g5v0d10v5 ad=0.7 pd=5.28 as=0.47105 ps=3.65 w=5 l=0.5
X207 sky130_fd_io__gpiov2_amux_0/sky130_fd_io__res75only_small_5/ROUT a_387_12076# VSSIO_Q VSSIO_Q sky130_fd_pr__nfet_g5v0d10v5 ad=0.7 pd=5.28 as=0.7 ps=5.28 w=5 l=0.5
X208 a_1225_12852# a_689_12820# a_1072_12852# VSSA sky130_fd_pr__nfet_g5v0d10v5 ad=0.21 pd=1.78 as=0.3975 ps=3.53 w=1.5 l=0.5
X209 VSSD a_13816_1289# a_13760_1103# VSSD sky130_fd_pr__nfet_01v8 ad=0.2627 pd=2.19 as=0.2109 ps=2.05 w=0.74 l=0.15
X210 sky130_fd_io__gpiov2_amux_0/sky130_fd_io__gpiov2_amux_ctl_logic_0/sky130_fd_io__gpiov2_amux_decoder_0/sky130_fd_io__inv_1_8/A a_2250_17651# a_12162_13064# VSSD sky130_fd_pr__nfet_g5v0d10v5 ad=1.325 pd=10.53 as=0.7 ps=5.28 w=5 l=0.5
X211 VSWITCH ENABLE_VSWITCH_H a_342_11805# VSWITCH sky130_fd_pr__pfet_g5v0d10v5 ad=0.265 pd=2.53 as=0.14 ps=1.28 w=1 l=0.6
X212 VSSD a_6543_11435# a_6367_11435# VSSD sky130_fd_pr__nfet_g5v0d10v5 ad=0.098 pd=0.98 as=0.098 ps=0.98 w=0.7 l=0.6
X213 VCCD a_6367_11435# a_6314_11461# VCCD sky130_fd_pr__pfet_g5v0d10v5 ad=0.14 pd=1.28 as=0.265 ps=2.53 w=1 l=0.6
X214 VSWITCH a_324_14186# a_1225_14186# VSWITCH sky130_fd_pr__pfet_g5v0d10v5 ad=0.098 pd=0.98 as=0.1855 ps=1.93 w=0.7 l=0.6
X215 VDDA a_620_17850# a_184_17734# VDDA sky130_fd_pr__pfet_g5v0d10v5 ad=0.0588 pd=0.7 as=0.1113 ps=1.37 w=0.42 l=1
X216 a_13970_2496# a_13760_1103# a_14053_2496# VSSD sky130_fd_pr__nfet_01v8_lvt ad=0.14 pd=1.28 as=0.14 ps=1.28 w=1 l=0.15
X217 a_9350_10698# a_282_14802# a_4110_14801# VSSD sky130_fd_pr__nfet_g5v0d10v5 ad=0.3975 pd=3.53 as=0.21 ps=1.78 w=1.5 l=0.5
X218 a_1077_11842# a_342_11805# VSSA VSSA sky130_fd_pr__nfet_g5v0d10v5 ad=0.265 pd=2.53 as=0.14 ps=1.28 w=1 l=0.5
X219 a_324_12852# a_1225_12852# VSWITCH VSWITCH sky130_fd_pr__pfet_g5v0d10v5 ad=0.1855 pd=1.93 as=0.098 ps=0.98 w=0.7 l=0.6
X220 VSSD sky130_fd_io__gpiov2_amux_0/sky130_fd_io__gpiov2_amux_ctl_logic_0/sky130_fd_io__gpiov2_amux_decoder_0/sky130_fd_io__inv_1_8/A a_275_9352# VSSD sky130_fd_pr__nfet_01v8_lvt ad=0.14 pd=1.28 as=0.14 ps=1.28 w=1 l=0.15
X221 VDDIO_Q a_13902_2778# a_231_9686# VDDIO_Q sky130_fd_pr__pfet_g5v0d10v5 ad=0.21 pd=1.78 as=0.3975 ps=3.53 w=1.5 l=0.5
X222 w_12765_14755# a_6367_11435# sky130_fd_io__gpiov2_amux_0/sky130_fd_io__res75only_small_7/ROUT VSSA sky130_fd_pr__nfet_g5v0d10v5 ad=0.84 pd=6.56 as=0.84 ps=6.56 w=3 l=0.5
X223 sky130_fd_io__gpiov2_amux_0/sky130_fd_io__amux_switch_1v2b_1/NG_AMX_VPMP_H a_1225_14186# VSWITCH VSWITCH sky130_fd_pr__pfet_g5v0d10v5 ad=0.14 pd=1.28 as=0.14 ps=1.28 w=1 l=0.6
X224 a_9067_10698# a_282_14802# a_3642_14801# VSSD sky130_fd_pr__nfet_g5v0d10v5 ad=0.21 pd=1.78 as=0.21 ps=1.78 w=1.5 l=0.5
X225 VSSIO_Q a_387_12076# sky130_fd_io__gpiov2_amux_0/sky130_fd_io__res75only_small_5/ROUT VSSIO_Q sky130_fd_pr__nfet_g5v0d10v5 ad=0.7 pd=5.28 as=0.7 ps=5.28 w=5 l=0.5
X226 a_10940_10272# VCCD a_11173_10272# VSSD sky130_fd_pr__nfet_05v0_nvt ad=0.265 pd=2.53 as=0.14 ps=1.28 w=1 l=0.9
X227 a_184_17734# a_478_17182# VSSA VSSA sky130_fd_pr__nfet_g5v0d10v5 ad=0.265 pd=2.53 as=0.14 ps=1.28 w=1 l=0.5
X228 VSSD sky130_fd_io__gpiov2_amux_0/sky130_fd_io__gpiov2_amux_ctl_logic_0/sky130_fd_io__gpiov2_amux_decoder_0/sky130_fd_io__inv_1_5/Y a_10583_10272# VSSD sky130_fd_pr__nfet_01v8_lvt ad=0.14 pd=1.28 as=0.14 ps=1.28 w=1 l=0.15
X229 a_8300_11461# sky130_fd_io__gpiov2_amux_0/sky130_fd_io__amux_switch_1v2b_0/PG_AMX_VDDA_H_N VCCD VCCD sky130_fd_pr__pfet_g5v0d10v5 ad=0.14 pd=1.28 as=0.265 ps=2.53 w=1 l=0.6
X230 VSSA a_1225_14186# sky130_fd_io__gpiov2_amux_0/sky130_fd_io__amux_switch_1v2b_1/NG_AMX_VPMP_H VSSA sky130_fd_pr__nfet_g5v0d10v5 ad=0.0588 pd=0.7 as=0.0588 ps=0.7 w=0.42 l=0.6
X231 a_497_17084# a_229_14828# VDDA VDDA sky130_fd_pr__pfet_g5v0d10v5 ad=0.1113 pd=1.37 as=0.0588 ps=0.7 w=0.42 l=1
X232 VSSA a_184_17734# sky130_fd_io__gpiov2_amux_0/sky130_fd_io__amux_switch_1v2b_0/PG_AMX_VDDA_H_N VSSA sky130_fd_pr__nfet_g5v0d10v5 ad=0.14 pd=1.28 as=0.265 ps=2.53 w=1 l=0.5
X233 a_2982_13760# VCCD a_2749_13760# VSSA sky130_fd_pr__nfet_05v0_nvt ad=0.14 pd=1.28 as=0.265 ps=2.53 w=1 l=0.9
X234 a_789_14186# VCCD a_421_13760# VSSA sky130_fd_pr__nfet_05v0_nvt ad=0.14 pd=1.28 as=0.265 ps=2.53 w=1 l=0.9
X235 VSSD sky130_fd_io__gpiov2_amux_0/sky130_fd_io__amux_switch_1v2b_1/NG_PAD_VPMP_H a_8067_11435# VSSD sky130_fd_pr__nfet_g5v0d10v5 ad=0.1855 pd=1.93 as=0.098 ps=0.98 w=0.7 l=0.6
X236 a_7015_11461# a_6895_11435# VCCD VCCD sky130_fd_pr__pfet_g5v0d10v5 ad=0.14 pd=1.28 as=0.14 ps=1.28 w=1 l=0.6
X237 VSWITCH a_1077_11842# a_377_12820# VSWITCH sky130_fd_pr__pfet_g5v0d10v5 ad=0.21 pd=1.78 as=0.3975 ps=3.53 w=1.5 l=0.5
X238 a_8765_11461# sky130_fd_io__gpiov2_amux_0/sky130_fd_io__amux_switch_1v2b_1/PG_AMX_VDDA_H_N VCCD VCCD sky130_fd_pr__pfet_g5v0d10v5 ad=0.14 pd=1.28 as=0.265 ps=2.53 w=1 l=0.6
X239 a_1077_11842# a_231_9686# a_3218_11709# VSSA sky130_fd_pr__nfet_g5v0d10v5 ad=0.795 pd=6.53 as=0.42 ps=3.28 w=3 l=0.5
X240 a_2250_17651# a_7173_10183# VSSD VSSD sky130_fd_pr__nfet_g5v0d10v5 ad=0.0588 pd=0.7 as=0.0588 ps=0.7 w=0.42 l=0.6
X241 VCCD sky130_fd_io__gpiov2_amux_0/sky130_fd_io__gpiov2_amux_ctl_logic_0/sky130_fd_io__gpiov2_amux_decoder_0/sky130_fd_io__inv_1_14/Y a_6895_11435# VCCD sky130_fd_pr__pfet_g5v0d10v5 ad=0.14 pd=1.28 as=0.14 ps=1.28 w=1 l=0.6
X242 a_643_9778# VCCD a_275_9352# VSSD sky130_fd_pr__nfet_05v0_nvt ad=0.14 pd=1.28 as=0.265 ps=2.53 w=1 l=0.9
X243 VDDIO_Q a_7173_10183# a_2250_17651# VDDIO_Q sky130_fd_pr__pfet_g5v0d10v5 ad=0.14 pd=1.28 as=0.14 ps=1.28 w=1 l=0.6
X244 a_324_12852# a_377_12820# VSSA VSSA sky130_fd_pr__nfet_g5v0d10v5 ad=0.21 pd=1.78 as=0.21 ps=1.78 w=1.5 l=0.5
X245 a_14092_2778# VCCD a_14053_2496# VSSD sky130_fd_pr__nfet_05v0_nvt ad=0.14 pd=1.28 as=0.14 ps=1.28 w=1 l=0.9
X246 VSSD a_8300_11461# a_7539_11435# VSSD sky130_fd_pr__nfet_g5v0d10v5 ad=0.196 pd=1.96 as=0.098 ps=0.98 w=0.7 l=0.6
X247 VSSA a_377_12820# a_324_12852# VSSA sky130_fd_pr__nfet_g5v0d10v5 ad=0.21 pd=1.78 as=0.3975 ps=3.53 w=1.5 l=0.5
X248 a_184_18182# a_4110_14801# a_3462_14827# VSSA sky130_fd_pr__nfet_g5v0d10v5 ad=0.795 pd=6.53 as=0.42 ps=3.28 w=3 l=0.5
X249 a_11080_13064# a_6314_11461# a_10924_13064# VSSD sky130_fd_pr__nfet_g5v0d10v5 ad=0.7 pd=5.28 as=0.7 ps=5.28 w=5 l=0.5
X250 a_2162_14426# a_377_12820# VSSA VSSA sky130_fd_pr__nfet_g5v0d10v5 ad=0.3975 pd=3.53 as=0.21 ps=1.78 w=1.5 l=0.5
X251 a_10350_10272# a_282_14802# a_10406_10767# VSSD sky130_fd_pr__nfet_g5v0d10v5 ad=0.3975 pd=3.53 as=0.21 ps=1.78 w=1.5 l=0.5
X252 a_13970_2496# sky130_fd_io__gpiov2_ctl_0/HLD_I_H_N VSSD VSSD sky130_fd_pr__nfet_g5v0d10v5 ad=0.14 pd=1.28 as=0.265 ps=2.53 w=1 l=0.5
X253 VCCD sky130_fd_io__gpiov2_amux_0/sky130_fd_io__gpiov2_amux_ctl_logic_0/sky130_fd_io__gpiov2_amux_decoder_0/sky130_fd_io__inv_1_9/A a_10643_12610# VCCD sky130_fd_pr__pfet_g5v0d10v5 ad=0.14 pd=1.28 as=0.14 ps=1.28 w=1 l=0.6
X254 VSSA ENABLE_VDDA_H a_382_14828# VSSA sky130_fd_pr__nfet_g5v0d10v5 ad=0.795 pd=6.53 as=0.795 ps=6.53 w=3 l=0.5
X255 a_3462_14827# a_4110_14801# a_184_18182# VSSA sky130_fd_pr__nfet_g5v0d10v5 ad=0.42 pd=3.28 as=0.42 ps=3.28 w=3 l=0.5
X256 a_3642_14801# a_4110_14801# VDDIO_Q VDDIO_Q sky130_fd_pr__pfet_g5v0d10v5 ad=0.1855 pd=1.93 as=0.098 ps=0.98 w=0.7 l=0.6
X257 a_4110_14801# a_282_14802# a_9350_10698# VSSD sky130_fd_pr__nfet_g5v0d10v5 ad=0.21 pd=1.78 as=0.3975 ps=3.53 w=1.5 l=0.5
X258 VCCD a_13816_1289# a_13760_1103# VCCD sky130_fd_pr__pfet_01v8_hvt ad=0.345 pd=2.69 as=0.295 ps=2.59 w=1 l=0.25
X259 a_12443_12112# sky130_fd_io__gpiov2_amux_0/sky130_fd_io__gpiov2_amux_ctl_logic_0/sky130_fd_io__gpiov2_amux_decoder_0/sky130_fd_io__inv_1_5/A VCCD VCCD sky130_fd_pr__pfet_g5v0d10v5 ad=0.14 pd=1.28 as=0.14 ps=1.28 w=1 l=0.6
X260 a_3642_14801# a_231_9686# VSSD VSSD sky130_fd_pr__nfet_g5v0d10v5 ad=0.21 pd=1.78 as=0.21 ps=1.78 w=1.5 l=0.5
X261 VDDIO_Q a_3642_14801# sky130_fd_io__gpiov2_amux_0/sky130_fd_io__amux_switch_1v2b_1/PG_PAD_VDDIOQ_H_N VDDIO_Q sky130_fd_pr__pfet_g5v0d10v5 ad=0.14 pd=1.28 as=0.14 ps=1.28 w=1 l=0.6
X262 a_275_9352# VCCD a_643_9778# VSSD sky130_fd_pr__nfet_05v0_nvt ad=0.265 pd=2.53 as=0.14 ps=1.28 w=1 l=0.9
X263 a_8473_11461# sky130_fd_io__gpiov2_amux_0/sky130_fd_io__amux_switch_1v2b_0/PG_AMX_VDDA_H_N a_8300_11461# VSSD sky130_fd_pr__nfet_g5v0d10v5 ad=0.098 pd=0.98 as=0.1855 ps=1.93 w=0.7 l=0.6
X264 a_7370_13247# sky130_fd_io__gpiov2_amux_0/sky130_fd_io__gpiov2_amux_ctl_logic_0/sky130_fd_io__gpiov2_amux_decoder_0/sky130_fd_io__inv_1_3/Y VSSD VSSD sky130_fd_pr__nfet_01v8 ad=0.1176 pd=1.12 as=0.2226 ps=2.21 w=0.84 l=0.15
X265 VDDIO_Q a_178_9778# a_1079_9778# VDDIO_Q sky130_fd_pr__pfet_g5v0d10v5 ad=0.098 pd=0.98 as=0.1855 ps=1.93 w=0.7 l=0.6
X266 VSSD a_231_9686# a_3642_14801# VSSD sky130_fd_pr__nfet_g5v0d10v5 ad=0.21 pd=1.78 as=0.3975 ps=3.53 w=1.5 l=0.5
X267 a_6367_11435# a_6543_11435# VCCD VCCD sky130_fd_pr__pfet_g5v0d10v5 ad=0.14 pd=1.28 as=0.14 ps=1.28 w=1 l=0.6
X268 sky130_fd_io__gpiov2_amux_0/sky130_fd_io__gpiov2_amux_ctl_logic_0/sky130_fd_io__gpiov2_amux_decoder_0/sky130_fd_io__inv_1_5/A sky130_fd_io__gpiov2_amux_0/sky130_fd_io__gpiov2_amux_ctl_logic_0/sky130_fd_io__gpiov2_amux_decoder_0/sky130_fd_io__nor2_1_1/Y VCCD VCCD sky130_fd_pr__pfet_g5v0d10v5 ad=0.14 pd=1.28 as=0.265 ps=2.53 w=1 l=0.6
X269 VCCD sky130_fd_io__gpiov2_amux_0/sky130_fd_io__amux_switch_1v2b_0/PG_PAD_VDDIOQ_H_N a_8300_11461# VCCD sky130_fd_pr__pfet_g5v0d10v5 ad=0.265 pd=2.53 as=0.14 ps=1.28 w=1 l=0.6
X270 VCCD sky130_fd_io__gpiov2_amux_0/sky130_fd_io__gpiov2_amux_ctl_logic_0/sky130_fd_io__gpiov2_amux_decoder_0/sky130_fd_io__nor2_1_2/Y sky130_fd_io__gpiov2_amux_0/sky130_fd_io__gpiov2_amux_ctl_logic_0/sky130_fd_io__gpiov2_amux_decoder_0/sky130_fd_io__inv_1_8/A VCCD sky130_fd_pr__pfet_g5v0d10v5 ad=0.14 pd=1.28 as=0.14 ps=1.28 w=1 l=0.6
X271 VSSA a_1024_11940# a_689_12820# VSSA sky130_fd_pr__nfet_g5v0d10v5 ad=0.265 pd=2.53 as=0.265 ps=2.53 w=1 l=0.5
X272 a_10583_10272# VCCD a_10350_10272# VSSD sky130_fd_pr__nfet_05v0_nvt ad=0.14 pd=1.28 as=0.265 ps=2.53 w=1 l=0.9
X273 a_7015_11461# a_6895_11435# VSSD VSSD sky130_fd_pr__nfet_g5v0d10v5 ad=0.098 pd=0.98 as=0.098 ps=0.98 w=0.7 l=0.6
X274 a_8938_11461# sky130_fd_io__gpiov2_amux_0/sky130_fd_io__amux_switch_1v2b_1/PG_AMX_VDDA_H_N a_8765_11461# VSSD sky130_fd_pr__nfet_g5v0d10v5 ad=0.098 pd=0.98 as=0.1855 ps=1.93 w=0.7 l=0.6
X275 a_421_13760# VCCD a_789_14186# VSSA sky130_fd_pr__nfet_05v0_nvt ad=0.265 pd=2.53 as=0.14 ps=1.28 w=1 l=0.9
X276 a_1072_14186# a_689_12820# a_1225_14186# VSSA sky130_fd_pr__nfet_g5v0d10v5 ad=0.3975 pd=3.53 as=0.21 ps=1.78 w=1.5 l=0.5
X277 a_3218_11709# a_231_9686# a_1077_11842# VSSA sky130_fd_pr__nfet_g5v0d10v5 ad=0.42 pd=3.28 as=0.42 ps=3.28 w=3 l=0.5
X278 VSSD sky130_fd_io__gpiov2_amux_0/sky130_fd_io__gpiov2_amux_ctl_logic_0/sky130_fd_io__gpiov2_amux_decoder_0/sky130_fd_io__inv_1_14/Y a_7659_11461# VSSD sky130_fd_pr__nfet_g5v0d10v5 ad=0.098 pd=0.98 as=0.098 ps=0.98 w=0.7 l=0.6
X279 a_178_9778# a_231_9686# VSSD VSSD sky130_fd_pr__nfet_g5v0d10v5 ad=0.21 pd=1.78 as=0.21 ps=1.78 w=1.5 l=0.5
X280 w_12765_16869# a_7015_11461# sky130_fd_io__gpiov2_amux_0/sky130_fd_io__res75only_small_9/ROUT VSSA sky130_fd_pr__nfet_g5v0d10v5 ad=0.84 pd=6.56 as=0.84 ps=6.56 w=3 l=0.5
X281 VSSD sky130_fd_io__gpiov2_amux_0/sky130_fd_io__gpiov2_amux_ctl_logic_0/sky130_fd_io__gpiov2_amux_decoder_0/sky130_fd_io__inv_1_7/A a_11131_11430# VSSD sky130_fd_pr__nfet_g5v0d10v5 ad=0.47105 pd=3.65 as=0.1113 ps=1.37 w=0.42 l=0.5
X282 a_497_17084# a_231_9686# a_382_14828# VSSA sky130_fd_pr__nfet_g5v0d10v5 ad=0.42 pd=3.28 as=0.42 ps=3.28 w=3 l=0.5
X283 a_7367_11461# a_7015_11461# VCCD VCCD sky130_fd_pr__pfet_g5v0d10v5 ad=0.265 pd=2.53 as=0.14 ps=1.28 w=1 l=0.6
X284 VSSD a_231_9686# a_7173_10183# VSSD sky130_fd_pr__nfet_g5v0d10v5 ad=0.21 pd=1.78 as=0.21 ps=1.78 w=1.5 l=0.5
X285 a_4259_12681# sky130_fd_io__gpiov2_amux_0/sky130_fd_io__amux_switch_1v2b_1/NG_PAD_VPMP_H VSSA VSSA sky130_fd_pr__nfet_g5v0d10v5 ad=0.19875 pd=2.03 as=0.19875 ps=2.03 w=0.75 l=0.5
X286 VSSD a_12443_12112# VSSD VSSD sky130_fd_pr__nfet_g5v0d10v5 ad=0.47105 pd=3.65 as=0 ps=0 w=0.42 l=0.5
X287 a_184_18182# a_4110_14801# a_3462_14827# VSSA sky130_fd_pr__nfet_g5v0d10v5 ad=0.42 pd=3.28 as=0.42 ps=3.28 w=3 l=0.5
X288 a_382_14828# a_282_14802# a_229_14828# VSSA sky130_fd_pr__nfet_g5v0d10v5 ad=0.42 pd=3.28 as=0.42 ps=3.28 w=3 l=0.5
X289 a_593_13378# VCCD a_1072_12852# VSSA sky130_fd_pr__nfet_05v0_nvt ad=0.14 pd=1.28 as=0.265 ps=2.53 w=1 l=0.9
X290 a_8871_10272# sky130_fd_io__gpiov2_amux_0/sky130_fd_io__gpiov2_amux_ctl_logic_0/sky130_fd_io__gpiov2_amux_decoder_0/sky130_fd_io__inv_1_9/Y VSSD VSSD sky130_fd_pr__nfet_01v8_lvt ad=0.14 pd=1.28 as=0.14 ps=1.28 w=1 l=0.15
X291 VSSA a_1225_12852# sky130_fd_io__gpiov2_amux_0/sky130_fd_io__amux_switch_1v2b_0/NG_PAD_VPMP_H VSSA sky130_fd_pr__nfet_g5v0d10v5 ad=0.1113 pd=1.37 as=0.0588 ps=0.7 w=0.42 l=0.6
X292 a_2162_14426# a_689_12820# a_2982_13760# VSSA sky130_fd_pr__nfet_g5v0d10v5 ad=0.21 pd=1.78 as=0.21 ps=1.78 w=1.5 l=0.5
X293 a_8871_10272# VCCD a_9350_10698# VSSD sky130_fd_pr__nfet_05v0_nvt ad=0.14 pd=1.28 as=0.265 ps=2.53 w=1 l=0.9
X294 a_926_9778# a_282_14802# a_1079_9778# VSSD sky130_fd_pr__nfet_g5v0d10v5 ad=0.3975 pd=3.53 as=0.21 ps=1.78 w=1.5 l=0.5
X295 VDDIO_Q a_178_9778# sky130_fd_io__gpiov2_amux_0/sky130_fd_io__amux_switch_1v2b_0/PG_PAD_VDDIOQ_H_N VDDIO_Q sky130_fd_pr__pfet_g5v0d10v5 ad=0.14 pd=1.28 as=0.14 ps=1.28 w=1 l=0.6
X296 VCCD sky130_fd_io__gpiov2_amux_0/sky130_fd_io__amux_switch_1v2b_1/PG_PAD_VDDIOQ_H_N a_8765_11461# VCCD sky130_fd_pr__pfet_g5v0d10v5 ad=0.265 pd=2.53 as=0.14 ps=1.28 w=1 l=0.6
X297 a_12006_13064# a_7367_11461# a_11850_13064# VSSD sky130_fd_pr__nfet_g5v0d10v5 ad=0.7 pd=5.28 as=0.7 ps=5.28 w=5 l=0.5
X298 VSSD sky130_fd_io__gpiov2_amux_0/sky130_fd_io__gpiov2_amux_ctl_logic_0/sky130_fd_io__gpiov2_amux_decoder_0/sky130_fd_io__inv_1_2/A a_11080_13064# VSSD sky130_fd_pr__nfet_g5v0d10v5 ad=0.47105 pd=3.65 as=0.7 ps=5.28 w=5 l=0.5
X299 VSSD a_7370_13247# sky130_fd_io__gpiov2_amux_0/sky130_fd_io__gpiov2_amux_ctl_logic_0/sky130_fd_io__gpiov2_amux_decoder_0/sky130_fd_io__nand2_1_1/B VSSD sky130_fd_pr__nfet_01v8 ad=0.4788 pd=2.82 as=0.2436 ps=1.42 w=0.84 l=0.15
X300 a_1024_12357# a_689_12820# a_2159_13760# VSSA sky130_fd_pr__nfet_g5v0d10v5 ad=0.21 pd=1.78 as=0.3975 ps=3.53 w=1.5 l=0.5
X301 sky130_fd_io__gpiov2_amux_0/sky130_fd_io__res75only_small_5/ROUT a_387_12076# VSSIO_Q VSSIO_Q sky130_fd_pr__nfet_g5v0d10v5 ad=0.7 pd=5.28 as=0.7 ps=5.28 w=5 l=0.5
X302 VSSD a_11523_13190# VSSD VSSD sky130_fd_pr__nfet_g5v0d10v5 ad=0.1113 pd=1.37 as=0 ps=0 w=0.42 l=0.5
X303 a_6543_11435# sky130_fd_io__gpiov2_amux_0/sky130_fd_io__gpiov2_amux_ctl_logic_0/sky130_fd_io__gpiov2_amux_decoder_0/sky130_fd_io__inv_1_2/Y VCCD VCCD sky130_fd_pr__pfet_g5v0d10v5 ad=0.14 pd=1.28 as=0.14 ps=1.28 w=1 l=0.6
X304 a_3462_14827# a_787_17182# VSSA VSSA sky130_fd_pr__nfet_g5v0d10v5 ad=0.795 pd=6.53 as=0.795 ps=6.53 w=3 l=0.5
X305 a_10705_12016# a_643_12102# a_10705_11860# VSSD sky130_fd_pr__nfet_g5v0d10v5 ad=0.7 pd=5.28 as=0.7 ps=5.28 w=5 l=0.5
X306 a_2250_17651# a_7173_10183# VSSD VSSD sky130_fd_pr__nfet_g5v0d10v5 ad=0.0588 pd=0.7 as=0.0588 ps=0.7 w=0.42 l=0.6
X307 a_2749_13760# VCCD a_2982_13760# VSSA sky130_fd_pr__nfet_05v0_nvt ad=0.265 pd=2.53 as=0.14 ps=1.28 w=1 l=0.9
X308 VSSA sky130_fd_io__gpiov2_amux_0/sky130_fd_io__gpiov2_amux_ctl_logic_0/sky130_fd_io__gpiov2_amux_decoder_0/sky130_fd_io__inv_1_9/Y a_593_13760# VSSA sky130_fd_pr__nfet_01v8_lvt ad=0.265 pd=2.53 as=0.14 ps=1.28 w=1 l=0.15
X309 VCCD a_8067_11435# a_6543_11435# VCCD sky130_fd_pr__pfet_g5v0d10v5 ad=0.265 pd=2.53 as=0.14 ps=1.28 w=1 l=0.6
X310 VSSA sky130_fd_io__gpiov2_amux_0/sky130_fd_io__gpiov2_amux_ctl_logic_0/sky130_fd_io__gpiov2_amux_decoder_0/sky130_fd_io__inv_1_7/Y a_2392_13760# VSSA sky130_fd_pr__nfet_01v8_lvt ad=0.14 pd=1.28 as=0.14 ps=1.28 w=1 l=0.15
X311 VCCD sky130_fd_io__gpiov2_amux_0/sky130_fd_io__gpiov2_amux_ctl_logic_0/sky130_fd_io__gpiov2_amux_decoder_0/sky130_fd_io__inv_1_2/A sky130_fd_io__gpiov2_amux_0/sky130_fd_io__gpiov2_amux_ctl_logic_0/sky130_fd_io__gpiov2_amux_decoder_0/sky130_fd_io__inv_1_9/A VCCD sky130_fd_pr__pfet_g5v0d10v5 ad=0.14 pd=1.28 as=0.14 ps=1.28 w=1 l=0.6
X312 a_342_11805# ENABLE_VSWITCH_H VSWITCH VSWITCH sky130_fd_pr__pfet_g5v0d10v5 ad=0.14 pd=1.28 as=0.265 ps=2.53 w=1 l=0.6
X313 a_6367_11435# a_6543_11435# VSSD VSSD sky130_fd_pr__nfet_g5v0d10v5 ad=0.098 pd=0.98 as=0.098 ps=0.98 w=0.7 l=0.6
X314 a_387_12076# a_231_9686# VSSA VSSA sky130_fd_pr__nfet_g5v0d10v5 ad=0.265 pd=2.53 as=0.265 ps=2.53 w=1 l=0.5
X315 a_13902_2778# a_14092_2778# VDDIO_Q VDDIO_Q sky130_fd_pr__pfet_g5v0d10v5 ad=0.19875 pd=2.03 as=0.19875 ps=2.03 w=0.75 l=0.5
X316 VCCD a_6543_11435# a_6367_11435# VCCD sky130_fd_pr__pfet_g5v0d10v5 ad=0.14 pd=1.28 as=0.14 ps=1.28 w=1 l=0.6
X317 VSWITCH a_324_12852# a_1225_12852# VSWITCH sky130_fd_pr__pfet_g5v0d10v5 ad=0.098 pd=0.98 as=0.1855 ps=1.93 w=0.7 l=0.6
X318 sky130_fd_io__gpiov2_amux_0/sky130_fd_io__amux_switch_1v2b_0/PG_PAD_VDDIOQ_H_N a_178_9778# VSSD VSSD sky130_fd_pr__nfet_g5v0d10v5 ad=0.0588 pd=0.7 as=0.1113 ps=1.37 w=0.42 l=0.6
X319 sky130_fd_io__gpiov2_amux_0/sky130_fd_io__amux_switch_1v2b_1/PG_PAD_VDDIOQ_H_N a_3642_14801# VSSD VSSD sky130_fd_pr__nfet_g5v0d10v5 ad=0.0588 pd=0.7 as=0.0588 ps=0.7 w=0.42 l=0.6
X320 a_14397_2496# VCCD a_13902_2778# VSSD sky130_fd_pr__nfet_05v0_nvt ad=0.265 pd=2.53 as=0.14 ps=1.28 w=1 l=0.9
X321 VDDIO_Q a_7173_10183# a_2250_17651# VDDIO_Q sky130_fd_pr__pfet_g5v0d10v5 ad=0.14 pd=1.28 as=0.14 ps=1.28 w=1 l=0.6
X322 VDDIO_Q a_7173_10183# a_2250_17651# VDDIO_Q sky130_fd_pr__pfet_g5v0d10v5 ad=0.14 pd=1.28 as=0.14 ps=1.28 w=1 l=0.6
X323 a_13902_2778# sky130_fd_io__gpiov2_ctl_0/sky130_fd_io__com_ctl_hldv2_0/HLD_I_H VSSD VSSD sky130_fd_pr__nfet_g5v0d10v5 ad=0.265 pd=2.53 as=0.14 ps=1.28 w=1 l=0.5
X324 a_10705_11860# a_4259_12681# a_10705_11704# VSSD sky130_fd_pr__nfet_g5v0d10v5 ad=0.7 pd=5.28 as=0.7 ps=5.28 w=5 l=0.5
X325 VSWITCH a_1225_12852# sky130_fd_io__gpiov2_amux_0/sky130_fd_io__amux_switch_1v2b_0/NG_AMX_VPMP_H VSWITCH sky130_fd_pr__pfet_g5v0d10v5 ad=0.14 pd=1.28 as=0.14 ps=1.28 w=1 l=0.6
X326 a_593_13378# sky130_fd_io__gpiov2_amux_0/sky130_fd_io__gpiov2_amux_ctl_logic_0/sky130_fd_io__gpiov2_amux_decoder_0/sky130_fd_io__inv_1_8/Y VSSA VSSA sky130_fd_pr__nfet_01v8_lvt ad=0.14 pd=1.28 as=0.14 ps=1.28 w=1 l=0.15
X327 VSSA sky130_fd_io__gpiov2_amux_0/sky130_fd_io__gpiov2_amux_ctl_logic_0/sky130_fd_io__gpiov2_amux_decoder_0/sky130_fd_io__inv_1_9/A a_421_13760# VSSA sky130_fd_pr__nfet_01v8_lvt ad=0.14 pd=1.28 as=0.14 ps=1.28 w=1 l=0.15
X328 a_1077_11842# a_231_9686# a_3218_11709# VSSA sky130_fd_pr__nfet_g5v0d10v5 ad=0.42 pd=3.28 as=0.42 ps=3.28 w=3 l=0.5
X329 a_387_12076# a_1024_12357# VSSA VSSA sky130_fd_pr__nfet_g5v0d10v5 ad=0.21 pd=1.78 as=0.3975 ps=3.53 w=1.5 l=0.5
X330 VSSD a_14092_2778# a_282_14802# VSSD sky130_fd_pr__nfet_g5v0d10v5 ad=0.14 pd=1.28 as=0.265 ps=2.53 w=1 l=0.5
X331 VSSD sky130_fd_io__gpiov2_ctl_0/HLD_I_H_N a_13970_2496# VSSD sky130_fd_pr__nfet_g5v0d10v5 ad=0.265 pd=2.53 as=0.14 ps=1.28 w=1 l=0.5
X332 VCCD sky130_fd_io__gpiov2_amux_0/sky130_fd_io__gpiov2_amux_ctl_logic_0/sky130_fd_io__gpiov2_amux_decoder_0/sky130_fd_io__inv_1_8/A a_11523_13190# VCCD sky130_fd_pr__pfet_g5v0d10v5 ad=0.15455 pd=1.37 as=0.14 ps=1.28 w=1 l=0.6
X333 VSSD sky130_fd_io__gpiov2_amux_0/sky130_fd_io__gpiov2_amux_ctl_logic_0/sky130_fd_io__gpiov2_amux_decoder_0/sky130_fd_io__inv_1_8/A a_11523_13190# VSSD sky130_fd_pr__nfet_g5v0d10v5 ad=0.47105 pd=3.65 as=0.1113 ps=1.37 w=0.42 l=0.5
X334 a_7367_11461# a_7015_11461# VSSD VSSD sky130_fd_pr__nfet_g5v0d10v5 ad=0.1855 pd=1.93 as=0.098 ps=0.98 w=0.7 l=0.6
X335 a_13970_2496# sky130_fd_io__gpiov2_ctl_0/HLD_I_H_N VSSD VSSD sky130_fd_pr__nfet_g5v0d10v5 ad=0.14 pd=1.28 as=0.14 ps=1.28 w=1 l=0.5
X336 a_12897_12016# a_643_12102# a_12897_11860# VSSD sky130_fd_pr__nfet_g5v0d10v5 ad=0.7 pd=5.28 as=0.7 ps=5.28 w=5 l=0.5
X337 a_11131_11430# sky130_fd_io__gpiov2_amux_0/sky130_fd_io__gpiov2_amux_ctl_logic_0/sky130_fd_io__gpiov2_amux_decoder_0/sky130_fd_io__inv_1_7/A VCCD VCCD sky130_fd_pr__pfet_g5v0d10v5 ad=0.14 pd=1.28 as=0.14 ps=1.28 w=1 l=0.6
X338 a_195_17182# ENABLE_VDDA_H VSSA VSSA sky130_fd_pr__nfet_g5v0d10v5 ad=0.265 pd=2.53 as=0.265 ps=2.53 w=1 l=0.5
X339 a_2250_17651# a_7173_10183# VSSD VSSD sky130_fd_pr__nfet_g5v0d10v5 ad=0.0588 pd=0.7 as=0.0588 ps=0.7 w=0.42 l=0.6
X340 VCCD sky130_fd_io__gpiov2_amux_0/sky130_fd_io__amux_switch_1v2b_1/NG_PAD_VPMP_H a_9877_11799# VCCD sky130_fd_pr__pfet_g5v0d10v5 ad=0.265 pd=2.53 as=0.14 ps=1.28 w=1 l=0.6
X341 a_382_14828# a_282_14802# a_229_14828# VSSA sky130_fd_pr__nfet_g5v0d10v5 ad=0.42 pd=3.28 as=0.795 ps=6.53 w=3 l=0.5
X342 VSSD sky130_fd_io__gpiov2_amux_0/sky130_fd_io__amux_switch_1v2b_1/PG_PAD_VDDIOQ_H_N a_8938_11461# VSSD sky130_fd_pr__nfet_g5v0d10v5 ad=0.1855 pd=1.93 as=0.098 ps=0.98 w=0.7 l=0.6
X343 sky130_fd_io__gpiov2_amux_0/sky130_fd_io__res75only_small_8/ROUT a_7015_11461# w_9674_16869# VSSA sky130_fd_pr__nfet_g5v0d10v5 ad=0.84 pd=6.56 as=0.84 ps=6.56 w=3 l=0.5
X344 a_421_13378# sky130_fd_io__gpiov2_amux_0/sky130_fd_io__gpiov2_amux_ctl_logic_0/sky130_fd_io__gpiov2_amux_decoder_0/sky130_fd_io__inv_1_8/A VSSA VSSA sky130_fd_pr__nfet_01v8_lvt ad=0.14 pd=1.28 as=0.265 ps=2.53 w=1 l=0.15
X345 sky130_fd_io__gpiov2_amux_0/sky130_fd_io__gpiov2_amux_ctl_logic_0/sky130_fd_io__gpiov2_amux_decoder_0/sky130_fd_io__inv_1_7/A sky130_fd_io__gpiov2_amux_0/sky130_fd_io__gpiov2_amux_ctl_logic_0/sky130_fd_io__gpiov2_amux_decoder_0/sky130_fd_io__nor2_1_3/Y VCCD VCCD sky130_fd_pr__pfet_g5v0d10v5 ad=0.14 pd=1.28 as=0.265 ps=2.53 w=1 l=0.6
X346 VSWITCH a_1225_14186# sky130_fd_io__gpiov2_amux_0/sky130_fd_io__amux_switch_1v2b_1/NG_PAD_VPMP_H VSWITCH sky130_fd_pr__pfet_g5v0d10v5 ad=0.14 pd=1.28 as=0.14 ps=1.28 w=1 l=0.6
X347 a_3462_14827# a_3642_14801# a_620_18182# VSSA sky130_fd_pr__nfet_g5v0d10v5 ad=0.42 pd=3.28 as=0.42 ps=3.28 w=3 l=0.5
X348 sky130_fd_io__gpiov2_amux_0/sky130_fd_io__res75only_small_4/ROUT a_387_12076# VSSIO_Q VSSIO_Q sky130_fd_pr__nfet_g5v0d10v5 ad=0.7 pd=5.28 as=0.7 ps=5.28 w=5 l=0.5
X349 VDDIO_Q a_10406_10767# a_7173_10183# VDDIO_Q sky130_fd_pr__pfet_g5v0d10v5 ad=0.098 pd=0.98 as=0.1855 ps=1.93 w=0.7 l=0.6
X350 a_8011_11461# sky130_fd_io__gpiov2_amux_0/sky130_fd_io__gpiov2_amux_ctl_logic_0/sky130_fd_io__gpiov2_amux_decoder_0/sky130_fd_io__inv_1_2/Y VSSD VSSD sky130_fd_pr__nfet_g5v0d10v5 ad=0.098 pd=0.98 as=0.098 ps=0.98 w=0.7 l=0.6
X351 a_620_18182# a_3642_14801# a_3462_14827# VSSA sky130_fd_pr__nfet_g5v0d10v5 ad=0.42 pd=3.28 as=0.42 ps=3.28 w=3 l=0.5
X352 VSSIO_Q a_387_12076# sky130_fd_io__gpiov2_amux_0/sky130_fd_io__res75only_small_4/ROUT VSSIO_Q sky130_fd_pr__nfet_g5v0d10v5 ad=0.7 pd=5.28 as=0.7 ps=5.28 w=5 l=0.5
X353 a_7539_11435# a_8300_11461# a_9406_11799# VCCD sky130_fd_pr__pfet_g5v0d10v5 ad=0.265 pd=2.53 as=0.14 ps=1.28 w=1 l=0.6
X354 VCCD sky130_fd_io__gpiov2_amux_0/sky130_fd_io__gpiov2_amux_ctl_logic_0/sky130_fd_io__gpiov2_amux_decoder_0/sky130_fd_io__inv_1_3/Y a_7621_13247# VCCD sky130_fd_pr__pfet_01v8_hvt ad=0.4786 pd=3.44 as=0.1764 ps=1.54 w=1.26 l=0.15
X355 a_282_14802# a_14092_2778# VDDIO_Q VDDIO_Q sky130_fd_pr__pfet_g5v0d10v5 ad=0.3975 pd=3.53 as=0.21 ps=1.78 w=1.5 l=0.5
X356 a_2392_13760# VCCD a_2159_13760# VSSA sky130_fd_pr__nfet_05v0_nvt ad=0.14 pd=1.28 as=0.265 ps=2.53 w=1 l=0.9
X357 a_12897_11860# a_4259_12681# a_12897_11704# VSSD sky130_fd_pr__nfet_g5v0d10v5 ad=0.7 pd=5.28 as=0.7 ps=5.28 w=5 l=0.5
X358 VSSA a_1077_11842# a_377_12820# VSSA sky130_fd_pr__nfet_g5v0d10v5 ad=0.14 pd=1.28 as=0.265 ps=2.53 w=1 l=0.5
X359 a_2250_17651# a_7173_10183# VSSD VSSD sky130_fd_pr__nfet_g5v0d10v5 ad=0.1113 pd=1.37 as=0.0588 ps=0.7 w=0.42 l=0.6
X360 VDDA a_184_17734# sky130_fd_io__gpiov2_amux_0/sky130_fd_io__amux_switch_1v2b_0/PG_AMX_VDDA_H_N VDDA sky130_fd_pr__pfet_g5v0d10v5 ad=0.265 pd=2.53 as=0.14 ps=1.28 w=1 l=0.5
X361 a_4259_12681# sky130_fd_io__gpiov2_amux_0/sky130_fd_io__amux_switch_1v2b_1/NG_PAD_VPMP_H VSWITCH VSWITCH sky130_fd_pr__pfet_g5v0d10v5 ad=0.3975 pd=3.53 as=0.3975 ps=3.53 w=1.5 l=0.5
X362 sky130_fd_io__gpiov2_amux_0/sky130_fd_io__res75only_small_4/ROUT a_2250_17651# VDDIO_Q VDDIO_Q sky130_fd_pr__pfet_g5v0d10v5 ad=2.1 pd=15.28 as=2.1 ps=15.28 w=15 l=0.5
X363 a_10940_10272# sky130_fd_io__gpiov2_amux_0/sky130_fd_io__gpiov2_amux_ctl_logic_0/sky130_fd_io__gpiov2_amux_decoder_0/sky130_fd_io__inv_1_1/Y VSSD VSSD sky130_fd_pr__nfet_01v8_lvt ad=0.14 pd=1.28 as=0.14 ps=1.28 w=1 l=0.15
X364 a_3218_11709# a_282_14802# a_1024_11940# VSSA sky130_fd_pr__nfet_g5v0d10v5 ad=0.42 pd=3.28 as=0.42 ps=3.28 w=3 l=0.5
X365 sky130_fd_io__gpiov2_amux_0/sky130_fd_io__amux_switch_1v2b_0/PG_AMX_VDDA_H_N a_184_17734# VDDA VDDA sky130_fd_pr__pfet_g5v0d10v5 ad=0.14 pd=1.28 as=0.265 ps=2.53 w=1 l=0.5
X366 sky130_fd_io__gpiov2_amux_0/sky130_fd_io__res75only_small_4/ROUT a_387_12076# VSSIO_Q VSSIO_Q sky130_fd_pr__nfet_g5v0d10v5 ad=0.7 pd=5.28 as=1.4 ps=10.56 w=5 l=0.5
X367 VDDIO_Q a_2250_17651# sky130_fd_io__gpiov2_amux_0/sky130_fd_io__res75only_small_5/ROUT VDDIO_Q sky130_fd_pr__pfet_g5v0d10v5 ad=2.1 pd=15.28 as=2.1 ps=15.28 w=15 l=0.5
X368 a_231_9686# a_13902_2778# VSSD VSSD sky130_fd_pr__nfet_g5v0d10v5 ad=0.265 pd=2.53 as=0.265 ps=2.53 w=1 l=0.5
X369 a_8300_11461# sky130_fd_io__gpiov2_amux_0/sky130_fd_io__amux_switch_1v2b_0/PG_AMX_VDDA_H_N VCCD VCCD sky130_fd_pr__pfet_g5v0d10v5 ad=0.14 pd=1.28 as=0.265 ps=2.53 w=1 l=0.6
X370 a_1024_11940# a_282_14802# a_3218_11709# VSSA sky130_fd_pr__nfet_g5v0d10v5 ad=0.42 pd=3.28 as=0.42 ps=3.28 w=3 l=0.5
X371 sky130_fd_io__gpiov2_amux_0/sky130_fd_io__amux_switch_1v2b_0/NG_AMX_VPMP_H a_1225_12852# VSSA VSSA sky130_fd_pr__nfet_g5v0d10v5 ad=0.0588 pd=0.7 as=0.1113 ps=1.37 w=0.42 l=0.6
X372 a_3218_11709# a_282_14802# a_1024_11940# VSSA sky130_fd_pr__nfet_g5v0d10v5 ad=0.42 pd=3.28 as=0.795 ps=6.53 w=3 l=0.5
X373 VSWITCH a_1225_14186# sky130_fd_io__gpiov2_amux_0/sky130_fd_io__amux_switch_1v2b_1/NG_AMX_VPMP_H VSWITCH sky130_fd_pr__pfet_g5v0d10v5 ad=0.14 pd=1.28 as=0.14 ps=1.28 w=1 l=0.6
X374 a_13902_2778# VCCD a_14397_2496# VSSD sky130_fd_pr__nfet_05v0_nvt ad=0.14 pd=1.28 as=0.265 ps=2.53 w=1 l=0.9
X375 VSSIO_Q a_387_12076# sky130_fd_io__gpiov2_amux_0/sky130_fd_io__res75only_small_5/ROUT VSSIO_Q sky130_fd_pr__nfet_g5v0d10v5 ad=1.4 pd=10.56 as=0.7 ps=5.28 w=5 l=0.5
X376 a_14053_2496# VCCD a_14092_2778# VSSD sky130_fd_pr__nfet_05v0_nvt ad=0.265 pd=2.53 as=0.14 ps=1.28 w=1 l=0.9
X377 a_7015_11461# a_6895_11435# VCCD VCCD sky130_fd_pr__pfet_g5v0d10v5 ad=0.14 pd=1.28 as=0.14 ps=1.28 w=1 l=0.6
X378 a_8765_11461# sky130_fd_io__gpiov2_amux_0/sky130_fd_io__amux_switch_1v2b_1/PG_AMX_VDDA_H_N VCCD VCCD sky130_fd_pr__pfet_g5v0d10v5 ad=0.14 pd=1.28 as=0.265 ps=2.53 w=1 l=0.6
X379 a_382_14828# a_231_9686# a_497_17084# VSSA sky130_fd_pr__nfet_g5v0d10v5 ad=0.42 pd=3.28 as=0.42 ps=3.28 w=3 l=0.5
X380 VCCD sky130_fd_io__gpiov2_amux_0/sky130_fd_io__gpiov2_amux_ctl_logic_0/sky130_fd_io__gpiov2_amux_decoder_0/sky130_fd_io__inv_1_14/Y a_6895_11435# VCCD sky130_fd_pr__pfet_g5v0d10v5 ad=0.14 pd=1.28 as=0.14 ps=1.28 w=1 l=0.6
X381 a_10583_10272# sky130_fd_io__gpiov2_amux_0/sky130_fd_io__gpiov2_amux_ctl_logic_0/sky130_fd_io__gpiov2_amux_decoder_0/sky130_fd_io__inv_1_5/Y VSSD VSSD sky130_fd_pr__nfet_01v8_lvt ad=0.14 pd=1.28 as=0.265 ps=2.53 w=1 l=0.15
X382 sky130_fd_io__gpiov2_amux_0/sky130_fd_io__amux_switch_1v2b_1/NG_AMX_VPMP_H a_478_17182# VSSA VSSA sky130_fd_pr__nfet_g5v0d10v5 ad=0.265 pd=2.53 as=0.14 ps=1.28 w=1 l=0.5
.ends

.subckt sky130_ef_io__gpiov2_pad DM[0] IB_MODE_SEL ENABLE_H ENABLE_INP_H SLOW VTRIP_SEL
+ ENABLE_VDDIO ENABLE_VDDA_H PAD_A_NOESD_H ANALOG_POL HLD_H_N w_9674_16462# DM[1]
+ w_12765_14348# DM[2] w_9674_14246# PAD_A_ESD_1_H ENABLE_VSWITCH_H TIE_HI_ESD TIE_LO_ESD
+ OE_N w_12765_16462# VSWITCH ANALOG_SEL IN_H VDDIO INP_DIS AMUXBUS_B OUT HLD_OVR
+ VCCD AMUXBUS_A PAD VCCHIB PAD_A_ESD_0_H ANALOG_EN VSSIO VDDA VDDIO_Q VSSIO_Q IN
+ VSSD VSSA
Xsky130_fd_io__top_gpiov2_0 ANALOG_EN DM[0] DM[1] DM[2] HLD_H_N HLD_OVR INP_DIS ENABLE_VDDA_H
+ VTRIP_SEL OE_N OUT SLOW TIE_LO_ESD PAD_A_ESD_0_H ANALOG_SEL ENABLE_INP_H PAD_A_ESD_1_H
+ TIE_HI_ESD ENABLE_H IB_MODE_SEL ENABLE_VSWITCH_H VSSIO_Q PAD_A_NOESD_H ANALOG_POL
+ ENABLE_VDDIO IN IN_H sky130_fd_io__top_gpiov2_0/sky130_fd_io__overlay_gpiov2_m4_0/sky130_fd_io__top_gpio_pad_0/b_1500_19531#
+ w_9674_16462# sky130_fd_io__top_gpiov2_0/sky130_fd_io__gpiov2_amux_0/sky130_fd_io__amux_switch_1v2b_1/PG_AMX_VDDA_H_N
+ w_12765_16462# w_12765_14348# w_9674_14246# VDDIO_Q VSWITCH VSSA PAD VDDIO VCCHIB
+ VDDA AMUXBUS_B AMUXBUS_A VSSIO VCCD VSSD sky130_fd_io__top_gpiov2
.ends

.subckt sky130_ef_io__gpiov2_pad_wrapped IN_H PAD_A_NOESD_H PAD_A_ESD_0_H PAD_A_ESD_1_H
+ DM[2] DM[1] DM[0] HLD_H_N IN INP_DIS IB_MODE_SEL ENABLE_H ENABLE_VDDA_H ENABLE_INP_H
+ OE_N TIE_HI_ESD TIE_LO_ESD SLOW VTRIP_SEL HLD_OVR ANALOG_EN ANALOG_SEL ENABLE_VDDIO
+ ENABLE_VSWITCH_H ANALOG_POL OUT VDDIO_Q w_9674_19062# VSSIO_Q w_12765_19062# VCCD
+ AMUXBUS_B AMUXBUS_A VSSIO VSWITCH VDDA w_12765_16948# VDDIO VSSA w_9674_16846# VSSD
+ PAD VCCHIB
Xgpio DM[0] IB_MODE_SEL ENABLE_H ENABLE_INP_H SLOW VTRIP_SEL ENABLE_VDDIO ENABLE_VDDA_H
+ PAD_A_NOESD_H ANALOG_POL HLD_H_N w_9674_19062# DM[1] w_12765_16948# DM[2] w_9674_16846#
+ PAD_A_ESD_1_H ENABLE_VSWITCH_H TIE_HI_ESD TIE_LO_ESD OE_N w_12765_19062# VSWITCH
+ ANALOG_SEL IN_H VDDIO INP_DIS AMUXBUS_B OUT HLD_OVR VCCD AMUXBUS_A PAD VCCHIB PAD_A_ESD_0_H
+ ANALOG_EN VSSIO VDDA VDDIO_Q VSSIO_Q IN VSSD VSSA sky130_ef_io__gpiov2_pad
.ends

.subckt sky130_fd_io__pad_esd m4_960_20017# m5_1354_20500#
R0 m4_960_20017# m5_1354_20500# sky130_fd_pr__res_generic_m5 w=252.96001 l=0.1
.ends

.subckt sky130_fd_io__com_busses_esd sky130_fd_io__com_bus_hookup_0/VCCHIB sky130_fd_io__pad_esd_0/m5_1354_20500#
+ sky130_fd_io__com_bus_hookup_0/VSSD sky130_fd_io__pad_esd_0/m4_960_20017# sky130_fd_io__com_bus_hookup_0/AMUXBUS_A
+ sky130_fd_io__com_bus_hookup_0/VCCD sky130_fd_io__com_bus_hookup_0/AMUXBUS_B sky130_fd_io__com_bus_hookup_0/VDDIO
+ sky130_fd_io__com_bus_hookup_0/VSSA sky130_fd_io__com_bus_hookup_0/VSSIO sky130_fd_io__com_bus_hookup_0/VSWITCH
+ sky130_fd_io__com_bus_hookup_0/VDDA sky130_fd_io__com_bus_hookup_0/VSSIO_Q sky130_fd_io__com_bus_hookup_0/VDDIO_Q
Xsky130_fd_io__pad_esd_0 sky130_fd_io__pad_esd_0/m4_960_20017# sky130_fd_io__pad_esd_0/m5_1354_20500#
+ sky130_fd_io__pad_esd
.ends

.subckt sky130_fd_io__top_ground_lvc_wpad PADISOR PADISOL VSSIO_Q VCCHIB VDDA VDDIO_Q
+ G_PAD SRC_BDY_LVC1 SRC_BDY_LVC2 BDY2_B2B DRN_LVC2 DRN_LVC1 G_CORE OGC_LVC AMUXBUS_B
+ VSSIO VDDIO VSSD VSWITCH VSSA AMUXBUS_A VCCD
Xsky130_fd_io__com_busses_esd_0 VCCHIB G_PAD VSSD G_CORE AMUXBUS_A VCCD AMUXBUS_B
+ VDDIO VSSA VSSIO VSWITCH VDDA VSSIO_Q VDDIO_Q sky130_fd_io__com_busses_esd
X0 SRC_BDY_LVC2 a_2872_5340# DRN_LVC2 SRC_BDY_LVC2 sky130_fd_pr__nfet_01v8 ad=3.5 pd=15 as=3.535 ps=8.01 w=7 l=0.18
X1 DRN_LVC1 a_450_404# SRC_BDY_LVC1 SRC_BDY_LVC1 sky130_fd_pr__nfet_01v8 ad=3.535 pd=8.01 as=3.5 ps=15 w=7 l=0.18
X2 SRC_BDY_LVC1 a_450_404# DRN_LVC1 SRC_BDY_LVC1 sky130_fd_pr__nfet_01v8 ad=3.5 pd=15 as=3.535 ps=8.01 w=7 l=0.18
X3 SRC_BDY_LVC2 a_2595_15129# SRC_BDY_LVC2 SRC_BDY_LVC2 sky130_fd_pr__nfet_01v8 ad=0.7 pd=5.28 as=0 ps=0 w=5 l=8
X4 DRN_LVC2 a_2872_5340# SRC_BDY_LVC2 SRC_BDY_LVC2 sky130_fd_pr__nfet_01v8 ad=3.535 pd=8.01 as=3.5 ps=15 w=7 l=0.18
X5 DRN_LVC2 a_2872_5340# SRC_BDY_LVC2 SRC_BDY_LVC2 sky130_fd_pr__nfet_01v8 ad=3.535 pd=8.01 as=3.5 ps=15 w=7 l=0.18
X6 SRC_BDY_LVC2 a_2872_5340# DRN_LVC2 SRC_BDY_LVC2 sky130_fd_pr__nfet_01v8 ad=3.5 pd=15 as=3.535 ps=8.01 w=7 l=0.18
X7 DRN_LVC1 a_414_306# a_450_404# DRN_LVC1 sky130_fd_pr__pfet_01v8 ad=0.98 pd=7.28 as=0.98 ps=7.28 w=7 l=0.18
X8 DRN_LVC2 a_2872_5340# SRC_BDY_LVC2 SRC_BDY_LVC2 sky130_fd_pr__nfet_01v8 ad=3.535 pd=8.01 as=3.5 ps=15 w=7 l=0.18
X9 SRC_BDY_LVC2 a_2872_5340# DRN_LVC2 SRC_BDY_LVC2 sky130_fd_pr__nfet_01v8 ad=3.5 pd=15 as=3.535 ps=8.01 w=7 l=0.18
X10 a_2872_5340# a_2595_15129# DRN_LVC2 DRN_LVC2 sky130_fd_pr__pfet_01v8 ad=0.98 pd=7.28 as=0.98 ps=7.28 w=7 l=0.18
X11 SRC_BDY_LVC1 a_414_306# SRC_BDY_LVC1 SRC_BDY_LVC1 sky130_fd_pr__nfet_01v8 ad=0.98 pd=7.28 as=0 ps=0 w=7 l=8
X12 SRC_BDY_LVC1 a_450_404# DRN_LVC1 SRC_BDY_LVC1 sky130_fd_pr__nfet_01v8 ad=5.625 pd=12.25 as=2.925 ps=6.17 w=5 l=0.18
X13 SRC_BDY_LVC2 a_2872_5340# DRN_LVC2 SRC_BDY_LVC2 sky130_fd_pr__nfet_01v8 ad=3.5 pd=15 as=3.535 ps=8.01 w=7 l=0.18
X14 DRN_LVC1 a_450_404# SRC_BDY_LVC1 SRC_BDY_LVC1 sky130_fd_pr__nfet_01v8 ad=4.095 pd=8.17 as=7.875 ps=16.25 w=7 l=0.18
X15 SRC_BDY_LVC1 a_450_404# DRN_LVC1 SRC_BDY_LVC1 sky130_fd_pr__nfet_01v8 ad=7.875 pd=16.25 as=4.095 ps=8.17 w=7 l=0.18
X16 SRC_BDY_LVC2 a_2595_15129# a_2872_5340# SRC_BDY_LVC2 sky130_fd_pr__nfet_01v8 ad=2.3975 pd=7.685 as=4.76 ps=15.36 w=7 l=0.18
X17 SRC_BDY_LVC2 a_2872_5340# DRN_LVC2 SRC_BDY_LVC2 sky130_fd_pr__nfet_01v8 ad=3.5 pd=15 as=3.535 ps=8.01 w=7 l=0.18
X18 DRN_LVC1 a_450_404# SRC_BDY_LVC1 SRC_BDY_LVC1 sky130_fd_pr__nfet_01v8 ad=4.095 pd=8.17 as=7.875 ps=16.25 w=7 l=0.18
X19 SRC_BDY_LVC2 a_2872_5340# DRN_LVC2 SRC_BDY_LVC2 sky130_fd_pr__nfet_01v8 ad=2.5 pd=11 as=2.525 ps=6.01 w=5 l=0.18
X20 DRN_LVC1 a_450_404# SRC_BDY_LVC1 SRC_BDY_LVC1 sky130_fd_pr__nfet_01v8 ad=2.925 pd=6.17 as=5.625 ps=12.25 w=5 l=0.18
X21 SRC_BDY_LVC2 a_2872_5340# DRN_LVC2 SRC_BDY_LVC2 sky130_fd_pr__nfet_01v8 ad=3.5 pd=15 as=3.535 ps=8.01 w=7 l=0.18
X22 SRC_BDY_LVC1 a_450_404# DRN_LVC1 SRC_BDY_LVC1 sky130_fd_pr__nfet_01v8 ad=7.875 pd=16.25 as=4.095 ps=8.17 w=7 l=0.18
X23 SRC_BDY_LVC1 a_450_404# DRN_LVC1 SRC_BDY_LVC1 sky130_fd_pr__nfet_01v8 ad=3.5 pd=15 as=3.535 ps=8.01 w=7 l=0.18
X24 a_450_404# a_414_306# DRN_LVC1 DRN_LVC1 sky130_fd_pr__pfet_01v8 ad=0.98 pd=7.28 as=0.98 ps=7.28 w=7 l=0.18
X25 SRC_BDY_LVC2 a_2872_5340# DRN_LVC2 SRC_BDY_LVC2 sky130_fd_pr__nfet_01v8 ad=3.5 pd=15 as=3.535 ps=8.01 w=7 l=0.18
X26 DRN_LVC1 a_450_404# SRC_BDY_LVC1 SRC_BDY_LVC1 sky130_fd_pr__nfet_01v8 ad=4.095 pd=8.17 as=7.875 ps=16.25 w=7 l=0.18
X27 DRN_LVC2 a_2872_5340# SRC_BDY_LVC2 SRC_BDY_LVC2 sky130_fd_pr__nfet_01v8 ad=3.535 pd=8.01 as=3.5 ps=15 w=7 l=0.18
X28 DRN_LVC2 a_2872_5340# SRC_BDY_LVC2 SRC_BDY_LVC2 sky130_fd_pr__nfet_01v8 ad=3.535 pd=8.01 as=3.5 ps=15 w=7 l=0.18
X29 DRN_LVC1 a_450_404# SRC_BDY_LVC1 SRC_BDY_LVC1 sky130_fd_pr__nfet_01v8 ad=2.925 pd=6.17 as=5.625 ps=12.25 w=5 l=0.18
X30 SRC_BDY_LVC1 a_450_404# DRN_LVC1 SRC_BDY_LVC1 sky130_fd_pr__nfet_01v8 ad=3.5 pd=15 as=3.535 ps=8.01 w=7 l=0.18
X31 DRN_LVC2 a_2872_5340# SRC_BDY_LVC2 SRC_BDY_LVC2 sky130_fd_pr__nfet_01v8 ad=3.535 pd=8.01 as=3.5 ps=15 w=7 l=0.18
X32 DRN_LVC1 a_450_404# SRC_BDY_LVC1 SRC_BDY_LVC1 sky130_fd_pr__nfet_01v8 ad=4.095 pd=8.17 as=7.875 ps=16.25 w=7 l=0.18
X33 SRC_BDY_LVC2 a_2872_5340# DRN_LVC2 SRC_BDY_LVC2 sky130_fd_pr__nfet_01v8 ad=3.5 pd=15 as=3.535 ps=8.01 w=7 l=0.18
X34 DRN_LVC1 a_450_404# SRC_BDY_LVC1 SRC_BDY_LVC1 sky130_fd_pr__nfet_01v8 ad=3.535 pd=8.01 as=3.5 ps=15 w=7 l=0.18
X35 SRC_BDY_LVC2 a_2872_5340# DRN_LVC2 SRC_BDY_LVC2 sky130_fd_pr__nfet_01v8 ad=3.5 pd=15 as=3.535 ps=8.01 w=7 l=0.18
X36 DRN_LVC1 a_414_306# a_450_404# DRN_LVC1 sky130_fd_pr__pfet_01v8 ad=0.98 pd=7.28 as=0.98 ps=7.28 w=7 l=0.18
X37 DRN_LVC2 a_2872_5340# SRC_BDY_LVC2 SRC_BDY_LVC2 sky130_fd_pr__nfet_01v8 ad=3.535 pd=8.01 as=3.5 ps=15 w=7 l=0.18
X38 SRC_BDY_LVC2 a_2872_5340# DRN_LVC2 SRC_BDY_LVC2 sky130_fd_pr__nfet_01v8 ad=3.5 pd=15 as=3.535 ps=8.01 w=7 l=0.18
X39 SRC_BDY_LVC2 a_2595_15129# SRC_BDY_LVC2 SRC_BDY_LVC2 sky130_fd_pr__nfet_01v8 ad=2.3975 pd=7.685 as=0 ps=0 w=7 l=8
X40 DRN_LVC1 a_414_306# a_450_404# DRN_LVC1 sky130_fd_pr__pfet_01v8 ad=0.98 pd=7.28 as=0.98 ps=7.28 w=7 l=0.18
X41 SRC_BDY_LVC1 a_414_306# SRC_BDY_LVC1 SRC_BDY_LVC1 sky130_fd_pr__nfet_01v8 ad=0.98 pd=7.28 as=0 ps=0 w=7 l=8
X42 SRC_BDY_LVC1 a_450_404# DRN_LVC1 SRC_BDY_LVC1 sky130_fd_pr__nfet_01v8 ad=7.875 pd=16.25 as=4.095 ps=8.17 w=7 l=0.18
X43 DRN_LVC2 a_2872_5340# SRC_BDY_LVC2 SRC_BDY_LVC2 sky130_fd_pr__nfet_01v8 ad=3.535 pd=8.01 as=3.5 ps=15 w=7 l=0.18
X44 SRC_BDY_LVC2 a_2872_5340# DRN_LVC2 SRC_BDY_LVC2 sky130_fd_pr__nfet_01v8 ad=3.5 pd=15 as=3.535 ps=8.01 w=7 l=0.18
X45 SRC_BDY_LVC1 a_450_404# DRN_LVC1 SRC_BDY_LVC1 sky130_fd_pr__nfet_01v8 ad=5.625 pd=12.25 as=2.925 ps=6.17 w=5 l=0.18
X46 a_450_404# a_414_306# DRN_LVC1 DRN_LVC1 sky130_fd_pr__pfet_01v8 ad=0.98 pd=7.28 as=1.96 ps=14.56 w=7 l=0.18
X47 DRN_LVC1 a_450_404# SRC_BDY_LVC1 SRC_BDY_LVC1 sky130_fd_pr__nfet_01v8 ad=4.095 pd=8.17 as=7.875 ps=16.25 w=7 l=0.18
X48 SRC_BDY_LVC1 a_450_404# DRN_LVC1 SRC_BDY_LVC1 sky130_fd_pr__nfet_01v8 ad=7.875 pd=16.25 as=4.095 ps=8.17 w=7 l=0.18
X49 a_414_306# DRN_LVC1 sky130_fd_pr__res_generic_po w=0.33 l=1.95k
X50 DRN_LVC1 a_450_404# SRC_BDY_LVC1 SRC_BDY_LVC1 sky130_fd_pr__nfet_01v8 ad=4.095 pd=8.17 as=7.875 ps=16.25 w=7 l=0.18
X51 DRN_LVC1 a_450_404# SRC_BDY_LVC1 SRC_BDY_LVC1 sky130_fd_pr__nfet_01v8 ad=2.925 pd=6.17 as=5.625 ps=12.25 w=5 l=0.18
X52 DRN_LVC2 a_2872_5340# SRC_BDY_LVC2 SRC_BDY_LVC2 sky130_fd_pr__nfet_01v8 ad=3.535 pd=8.01 as=3.5 ps=15 w=7 l=0.18
X53 SRC_BDY_LVC2 a_2872_5340# DRN_LVC2 SRC_BDY_LVC2 sky130_fd_pr__nfet_01v8 ad=3.5 pd=15 as=3.535 ps=8.01 w=7 l=0.18
X54 SRC_BDY_LVC1 a_450_404# DRN_LVC1 SRC_BDY_LVC1 sky130_fd_pr__nfet_01v8 ad=7.875 pd=16.25 as=4.095 ps=8.17 w=7 l=0.18
X55 SRC_BDY_LVC1 a_450_404# DRN_LVC1 SRC_BDY_LVC1 sky130_fd_pr__nfet_01v8 ad=3.5 pd=15 as=3.535 ps=8.01 w=7 l=0.18
X56 DRN_LVC1 a_450_404# SRC_BDY_LVC1 SRC_BDY_LVC1 sky130_fd_pr__nfet_01v8 ad=3.535 pd=8.01 as=3.5 ps=15 w=7 l=0.18
X57 SRC_BDY_LVC1 a_450_404# DRN_LVC1 SRC_BDY_LVC1 sky130_fd_pr__nfet_01v8 ad=7.875 pd=16.25 as=4.095 ps=8.17 w=7 l=0.18
X58 DRN_LVC2 a_2872_5340# SRC_BDY_LVC2 SRC_BDY_LVC2 sky130_fd_pr__nfet_01v8 ad=3.535 pd=8.01 as=3.5 ps=15 w=7 l=0.18
X59 a_450_404# a_414_306# DRN_LVC1 DRN_LVC1 sky130_fd_pr__pfet_01v8 ad=0.98 pd=7.28 as=0.98 ps=7.28 w=7 l=0.18
X60 DRN_LVC2 a_2872_5340# SRC_BDY_LVC2 SRC_BDY_LVC2 sky130_fd_pr__nfet_01v8 ad=2.525 pd=6.01 as=2.5 ps=11 w=5 l=0.18
X61 DRN_LVC2 a_2872_5340# SRC_BDY_LVC2 SRC_BDY_LVC2 sky130_fd_pr__nfet_01v8 ad=3.535 pd=8.01 as=3.5 ps=15 w=7 l=0.18
X62 SRC_BDY_LVC2 a_2872_5340# DRN_LVC2 SRC_BDY_LVC2 sky130_fd_pr__nfet_01v8 ad=3.5 pd=15 as=3.535 ps=8.01 w=7 l=0.18
X63 DRN_LVC1 a_450_404# SRC_BDY_LVC1 SRC_BDY_LVC1 sky130_fd_pr__nfet_01v8 ad=4.095 pd=8.17 as=7.875 ps=16.25 w=7 l=0.18
X64 a_2183_16816# a_2595_15129# sky130_fd_pr__res_generic_po w=0.33 l=200
X65 SRC_BDY_LVC1 a_450_404# DRN_LVC1 SRC_BDY_LVC1 sky130_fd_pr__nfet_01v8 ad=3.5 pd=15 as=3.535 ps=8.01 w=7 l=0.18
X66 DRN_LVC2 a_2595_15129# a_2872_5340# DRN_LVC2 sky130_fd_pr__pfet_01v8 ad=0.98 pd=7.28 as=0.98 ps=7.28 w=7 l=0.18
X67 DRN_LVC2 a_2872_5340# SRC_BDY_LVC2 SRC_BDY_LVC2 sky130_fd_pr__nfet_01v8 ad=3.535 pd=8.01 as=3.5 ps=15 w=7 l=0.18
X68 DRN_LVC1 a_450_404# SRC_BDY_LVC1 SRC_BDY_LVC1 sky130_fd_pr__nfet_01v8 ad=4.095 pd=8.17 as=7.875 ps=16.25 w=7 l=0.18
X69 SRC_BDY_LVC2 a_2872_5340# DRN_LVC2 SRC_BDY_LVC2 sky130_fd_pr__nfet_01v8 ad=3.5 pd=15 as=3.535 ps=8.01 w=7 l=0.18
X70 SRC_BDY_LVC2 a_2595_15129# SRC_BDY_LVC2 SRC_BDY_LVC2 sky130_fd_pr__nfet_01v8 ad=0.98 pd=7.28 as=0 ps=0 w=7 l=8
X71 DRN_LVC1 a_450_404# SRC_BDY_LVC1 SRC_BDY_LVC1 sky130_fd_pr__nfet_01v8 ad=3.535 pd=8.01 as=3.5 ps=15 w=7 l=0.18
X72 SRC_BDY_LVC1 a_450_404# DRN_LVC1 SRC_BDY_LVC1 sky130_fd_pr__nfet_01v8 ad=7.875 pd=16.25 as=4.095 ps=8.17 w=7 l=0.18
X73 DRN_LVC2 a_2872_5340# SRC_BDY_LVC2 SRC_BDY_LVC2 sky130_fd_pr__nfet_01v8 ad=2.525 pd=6.01 as=2.5 ps=11 w=5 l=0.18
X74 SRC_BDY_LVC2 a_2872_5340# DRN_LVC2 SRC_BDY_LVC2 sky130_fd_pr__nfet_01v8 ad=3.5 pd=15 as=3.535 ps=8.01 w=7 l=0.18
X75 SRC_BDY_LVC2 a_2595_15129# SRC_BDY_LVC2 SRC_BDY_LVC2 sky130_fd_pr__nfet_01v8 ad=0.98 pd=7.28 as=0 ps=0 w=7 l=8
X76 SRC_BDY_LVC1 a_450_404# DRN_LVC1 SRC_BDY_LVC1 sky130_fd_pr__nfet_01v8 ad=5.625 pd=12.25 as=2.925 ps=6.17 w=5 l=0.18
X77 SRC_BDY_LVC1 a_450_404# DRN_LVC1 SRC_BDY_LVC1 sky130_fd_pr__nfet_01v8 ad=7.875 pd=16.25 as=4.095 ps=8.17 w=7 l=0.18
X78 SRC_BDY_LVC2 a_2872_5340# DRN_LVC2 SRC_BDY_LVC2 sky130_fd_pr__nfet_01v8 ad=3.5 pd=15 as=3.535 ps=8.01 w=7 l=0.18
X79 DRN_LVC1 a_450_404# SRC_BDY_LVC1 SRC_BDY_LVC1 sky130_fd_pr__nfet_01v8 ad=4.095 pd=8.17 as=7.875 ps=16.25 w=7 l=0.18
X80 DRN_LVC2 a_2872_5340# SRC_BDY_LVC2 SRC_BDY_LVC2 sky130_fd_pr__nfet_01v8 ad=2.525 pd=6.01 as=2.5 ps=11 w=5 l=0.18
X81 SRC_BDY_LVC1 a_450_404# DRN_LVC1 SRC_BDY_LVC1 sky130_fd_pr__nfet_01v8 ad=3.5 pd=15 as=3.535 ps=8.01 w=7 l=0.18
X82 DRN_LVC2 a_2872_5340# SRC_BDY_LVC2 SRC_BDY_LVC2 sky130_fd_pr__nfet_01v8 ad=2.525 pd=6.01 as=2.5 ps=11 w=5 l=0.18
X83 SRC_BDY_LVC2 a_2872_5340# DRN_LVC2 SRC_BDY_LVC2 sky130_fd_pr__nfet_01v8 ad=2.5 pd=11 as=2.525 ps=6.01 w=5 l=0.18
X84 a_1871_4484# a_13955_3836# sky130_fd_pr__res_generic_po w=0.33 l=300
X85 DRN_LVC2 a_2595_15129# a_2872_5340# DRN_LVC2 sky130_fd_pr__pfet_01v8 ad=0.98 pd=7.28 as=0.98 ps=7.28 w=7 l=0.18
X86 DRN_LVC2 a_2872_5340# SRC_BDY_LVC2 SRC_BDY_LVC2 sky130_fd_pr__nfet_01v8 ad=2.525 pd=6.01 as=2.5 ps=11 w=5 l=0.18
X87 DRN_LVC2 a_2872_5340# SRC_BDY_LVC2 SRC_BDY_LVC2 sky130_fd_pr__nfet_01v8 ad=3.535 pd=8.01 as=3.5 ps=15 w=7 l=0.18
X88 DRN_LVC2 a_2872_5340# SRC_BDY_LVC2 SRC_BDY_LVC2 sky130_fd_pr__nfet_01v8 ad=3.535 pd=8.01 as=3.5 ps=15 w=7 l=0.18
X89 SRC_BDY_LVC2 a_2595_15129# SRC_BDY_LVC2 SRC_BDY_LVC2 sky130_fd_pr__nfet_01v8 ad=0.7 pd=5.28 as=0 ps=0 w=5 l=8
X90 DRN_LVC1 a_450_404# SRC_BDY_LVC1 SRC_BDY_LVC1 sky130_fd_pr__nfet_01v8 ad=4.095 pd=8.17 as=7.875 ps=16.25 w=7 l=0.18
X91 SRC_BDY_LVC1 a_450_404# DRN_LVC1 SRC_BDY_LVC1 sky130_fd_pr__nfet_01v8 ad=7.875 pd=16.25 as=4.095 ps=8.17 w=7 l=0.18
X92 DRN_LVC2 a_2872_5340# SRC_BDY_LVC2 SRC_BDY_LVC2 sky130_fd_pr__nfet_01v8 ad=3.535 pd=8.01 as=3.5 ps=15 w=7 l=0.18
X93 DRN_LVC1 a_450_404# SRC_BDY_LVC1 SRC_BDY_LVC1 sky130_fd_pr__nfet_01v8 ad=3.535 pd=8.01 as=3.5 ps=15 w=7 l=0.18
X94 SRC_BDY_LVC2 a_2872_5340# DRN_LVC2 SRC_BDY_LVC2 sky130_fd_pr__nfet_01v8 ad=2.5 pd=11 as=2.525 ps=6.01 w=5 l=0.18
X95 SRC_BDY_LVC1 a_450_404# DRN_LVC1 SRC_BDY_LVC1 sky130_fd_pr__nfet_01v8 ad=3.5 pd=15 as=3.535 ps=8.01 w=7 l=0.18
X96 DRN_LVC2 a_2872_5340# SRC_BDY_LVC2 SRC_BDY_LVC2 sky130_fd_pr__nfet_01v8 ad=3.535 pd=8.01 as=3.5 ps=15 w=7 l=0.18
X97 SRC_BDY_LVC2 a_2872_5340# DRN_LVC2 SRC_BDY_LVC2 sky130_fd_pr__nfet_01v8 ad=3.5 pd=15 as=3.535 ps=8.01 w=7 l=0.18
X98 DRN_LVC2 a_2872_5340# SRC_BDY_LVC2 SRC_BDY_LVC2 sky130_fd_pr__nfet_01v8 ad=3.535 pd=8.01 as=3.5 ps=15 w=7 l=0.18
X99 SRC_BDY_LVC1 a_414_306# a_450_404# SRC_BDY_LVC1 sky130_fd_pr__nfet_01v8 ad=2.3975 pd=7.685 as=4.76 ps=15.36 w=7 l=0.18
X100 DRN_LVC2 a_2872_5340# SRC_BDY_LVC2 SRC_BDY_LVC2 sky130_fd_pr__nfet_01v8 ad=3.535 pd=8.01 as=3.5 ps=15 w=7 l=0.18
X101 SRC_BDY_LVC2 a_2872_5340# DRN_LVC2 SRC_BDY_LVC2 sky130_fd_pr__nfet_01v8 ad=3.5 pd=15 as=3.535 ps=8.01 w=7 l=0.18
X102 SRC_BDY_LVC1 a_414_306# SRC_BDY_LVC1 SRC_BDY_LVC1 sky130_fd_pr__nfet_01v8 ad=2.3975 pd=7.685 as=0 ps=0 w=7 l=8
X103 DRN_LVC1 a_450_404# SRC_BDY_LVC1 SRC_BDY_LVC1 sky130_fd_pr__nfet_01v8 ad=3.535 pd=8.01 as=3.5 ps=15 w=7 l=0.18
X104 DRN_LVC1 a_450_404# SRC_BDY_LVC1 SRC_BDY_LVC1 sky130_fd_pr__nfet_01v8 ad=2.925 pd=6.17 as=5.625 ps=12.25 w=5 l=0.18
X105 DRN_LVC2 a_2872_5340# SRC_BDY_LVC2 SRC_BDY_LVC2 sky130_fd_pr__nfet_01v8 ad=3.535 pd=8.01 as=3.5 ps=15 w=7 l=0.18
X106 SRC_BDY_LVC2 a_2872_5340# DRN_LVC2 SRC_BDY_LVC2 sky130_fd_pr__nfet_01v8 ad=2.5 pd=11 as=2.525 ps=6.01 w=5 l=0.18
X107 DRN_LVC2 a_2595_15129# a_2872_5340# DRN_LVC2 sky130_fd_pr__pfet_01v8 ad=0.98 pd=7.28 as=0.98 ps=7.28 w=7 l=0.18
X108 SRC_BDY_LVC2 a_2872_5340# DRN_LVC2 SRC_BDY_LVC2 sky130_fd_pr__nfet_01v8 ad=3.5 pd=15 as=3.535 ps=8.01 w=7 l=0.18
X109 SRC_BDY_LVC2 a_2872_5340# DRN_LVC2 SRC_BDY_LVC2 sky130_fd_pr__nfet_01v8 ad=2.5 pd=11 as=2.525 ps=6.01 w=5 l=0.18
X110 DRN_LVC1 a_450_404# SRC_BDY_LVC1 SRC_BDY_LVC1 sky130_fd_pr__nfet_01v8 ad=3.535 pd=8.01 as=3.5 ps=15 w=7 l=0.18
X111 DRN_LVC2 a_2872_5340# SRC_BDY_LVC2 SRC_BDY_LVC2 sky130_fd_pr__nfet_01v8 ad=3.535 pd=8.01 as=3.5 ps=15 w=7 l=0.18
X112 SRC_BDY_LVC1 a_450_404# DRN_LVC1 SRC_BDY_LVC1 sky130_fd_pr__nfet_01v8 ad=7.875 pd=16.25 as=4.095 ps=8.17 w=7 l=0.18
X113 SRC_BDY_LVC1 BDY2_B2B sky130_fd_pr__diode_pd2nw_05v5 perim=3.3e+07 area=2.25e+13
X114 DRN_LVC2 a_2872_5340# SRC_BDY_LVC2 SRC_BDY_LVC2 sky130_fd_pr__nfet_01v8 ad=3.535 pd=8.01 as=3.5 ps=15 w=7 l=0.18
X115 SRC_BDY_LVC1 a_450_404# DRN_LVC1 SRC_BDY_LVC1 sky130_fd_pr__nfet_01v8 ad=7.875 pd=16.25 as=4.095 ps=8.17 w=7 l=0.18
X116 DRN_LVC2 a_2872_5340# SRC_BDY_LVC2 SRC_BDY_LVC2 sky130_fd_pr__nfet_01v8 ad=2.525 pd=6.01 as=2.5 ps=11 w=5 l=0.18
X117 DRN_LVC2 a_2872_5340# SRC_BDY_LVC2 SRC_BDY_LVC2 sky130_fd_pr__nfet_01v8 ad=3.535 pd=8.01 as=3.5 ps=15 w=7 l=0.18
X118 DRN_LVC1 a_450_404# SRC_BDY_LVC1 SRC_BDY_LVC1 sky130_fd_pr__nfet_01v8 ad=4.095 pd=8.17 as=7.875 ps=16.25 w=7 l=0.18
X119 SRC_BDY_LVC1 a_450_404# DRN_LVC1 SRC_BDY_LVC1 sky130_fd_pr__nfet_01v8 ad=3.5 pd=15 as=3.535 ps=8.01 w=7 l=0.18
X120 a_2872_5340# a_2595_15129# DRN_LVC2 DRN_LVC2 sky130_fd_pr__pfet_01v8 ad=0.98 pd=7.28 as=0.98 ps=7.28 w=7 l=0.18
X121 DRN_LVC1 a_450_404# SRC_BDY_LVC1 SRC_BDY_LVC1 sky130_fd_pr__nfet_01v8 ad=4.095 pd=8.17 as=7.875 ps=16.25 w=7 l=0.18
X122 SRC_BDY_LVC2 a_2872_5340# DRN_LVC2 SRC_BDY_LVC2 sky130_fd_pr__nfet_01v8 ad=3.5 pd=15 as=3.535 ps=8.01 w=7 l=0.18
X123 DRN_LVC2 a_2872_5340# SRC_BDY_LVC2 SRC_BDY_LVC2 sky130_fd_pr__nfet_01v8 ad=3.535 pd=8.01 as=3.5 ps=15 w=7 l=0.18
X124 BDY2_B2B SRC_BDY_LVC1 sky130_fd_pr__diode_pd2nw_05v5 perim=3.3e+07 area=2.25e+13
X125 SRC_BDY_LVC2 a_2872_5340# DRN_LVC2 SRC_BDY_LVC2 sky130_fd_pr__nfet_01v8 ad=3.5 pd=15 as=3.535 ps=8.01 w=7 l=0.18
X126 DRN_LVC2 a_2872_5340# SRC_BDY_LVC2 SRC_BDY_LVC2 sky130_fd_pr__nfet_01v8 ad=3.535 pd=8.01 as=3.5 ps=15 w=7 l=0.18
X127 DRN_LVC1 a_450_404# SRC_BDY_LVC1 SRC_BDY_LVC1 sky130_fd_pr__nfet_01v8 ad=4.095 pd=8.17 as=7.875 ps=16.25 w=7 l=0.18
X128 DRN_LVC2 a_2872_5340# SRC_BDY_LVC2 SRC_BDY_LVC2 sky130_fd_pr__nfet_01v8 ad=3.535 pd=8.01 as=3.5 ps=15 w=7 l=0.18
X129 DRN_LVC2 a_2872_5340# SRC_BDY_LVC2 SRC_BDY_LVC2 sky130_fd_pr__nfet_01v8 ad=3.535 pd=8.01 as=3.5 ps=15 w=7 l=0.18
X130 DRN_LVC2 a_2872_5340# SRC_BDY_LVC2 SRC_BDY_LVC2 sky130_fd_pr__nfet_01v8 ad=3.535 pd=8.01 as=3.5 ps=15 w=7 l=0.18
X131 SRC_BDY_LVC2 a_2872_5340# DRN_LVC2 SRC_BDY_LVC2 sky130_fd_pr__nfet_01v8 ad=3.5 pd=15 as=3.535 ps=8.01 w=7 l=0.18
X132 SRC_BDY_LVC2 a_2595_15129# SRC_BDY_LVC2 SRC_BDY_LVC2 sky130_fd_pr__nfet_01v8 ad=0.98 pd=7.28 as=0 ps=0 w=7 l=8
X133 SRC_BDY_LVC1 a_450_404# DRN_LVC1 SRC_BDY_LVC1 sky130_fd_pr__nfet_01v8 ad=3.5 pd=15 as=3.535 ps=8.01 w=7 l=0.18
X134 DRN_LVC1 a_450_404# SRC_BDY_LVC1 SRC_BDY_LVC1 sky130_fd_pr__nfet_01v8 ad=2.925 pd=6.17 as=5.625 ps=12.25 w=5 l=0.18
X135 DRN_LVC1 a_450_404# SRC_BDY_LVC1 SRC_BDY_LVC1 sky130_fd_pr__nfet_01v8 ad=4.095 pd=8.17 as=7.875 ps=16.25 w=7 l=0.18
X136 DRN_LVC2 a_2872_5340# SRC_BDY_LVC2 SRC_BDY_LVC2 sky130_fd_pr__nfet_01v8 ad=3.535 pd=8.01 as=3.5 ps=15 w=7 l=0.18
X137 SRC_BDY_LVC1 a_450_404# DRN_LVC1 SRC_BDY_LVC1 sky130_fd_pr__nfet_01v8 ad=3.5 pd=15 as=3.535 ps=8.01 w=7 l=0.18
X138 DRN_LVC2 a_2872_5340# SRC_BDY_LVC2 SRC_BDY_LVC2 sky130_fd_pr__nfet_01v8 ad=3.535 pd=8.01 as=3.5 ps=15 w=7 l=0.18
X139 SRC_BDY_LVC2 a_2872_5340# DRN_LVC2 SRC_BDY_LVC2 sky130_fd_pr__nfet_01v8 ad=3.5 pd=15 as=3.535 ps=8.01 w=7 l=0.18
X140 SRC_BDY_LVC2 a_2872_5340# DRN_LVC2 SRC_BDY_LVC2 sky130_fd_pr__nfet_01v8 ad=3.5 pd=15 as=3.535 ps=8.01 w=7 l=0.18
X141 SRC_BDY_LVC1 a_414_306# SRC_BDY_LVC1 SRC_BDY_LVC1 sky130_fd_pr__nfet_01v8 ad=2.3975 pd=7.685 as=0 ps=0 w=7 l=8
X142 SRC_BDY_LVC2 a_2872_5340# DRN_LVC2 SRC_BDY_LVC2 sky130_fd_pr__nfet_01v8 ad=3.5 pd=15 as=3.535 ps=8.01 w=7 l=0.18
X143 DRN_LVC1 a_450_404# SRC_BDY_LVC1 SRC_BDY_LVC1 sky130_fd_pr__nfet_01v8 ad=4.095 pd=8.17 as=7.875 ps=16.25 w=7 l=0.18
X144 a_2872_5340# a_2595_15129# DRN_LVC2 DRN_LVC2 sky130_fd_pr__pfet_01v8 ad=0.98 pd=7.28 as=1.96 ps=14.56 w=7 l=0.18
X145 SRC_BDY_LVC1 a_414_306# SRC_BDY_LVC1 SRC_BDY_LVC1 sky130_fd_pr__nfet_01v8 ad=0.98 pd=7.28 as=0 ps=0 w=7 l=8
X146 DRN_LVC1 a_450_404# SRC_BDY_LVC1 SRC_BDY_LVC1 sky130_fd_pr__nfet_01v8 ad=3.535 pd=8.01 as=3.5 ps=15 w=7 l=0.18
X147 SRC_BDY_LVC2 a_2872_5340# DRN_LVC2 SRC_BDY_LVC2 sky130_fd_pr__nfet_01v8 ad=3.5 pd=15 as=3.535 ps=8.01 w=7 l=0.18
X148 SRC_BDY_LVC2 a_2872_5340# DRN_LVC2 SRC_BDY_LVC2 sky130_fd_pr__nfet_01v8 ad=3.5 pd=15 as=3.535 ps=8.01 w=7 l=0.18
X149 SRC_BDY_LVC2 a_2872_5340# DRN_LVC2 SRC_BDY_LVC2 sky130_fd_pr__nfet_01v8 ad=3.5 pd=15 as=3.535 ps=8.01 w=7 l=0.18
X150 DRN_LVC1 a_450_404# SRC_BDY_LVC1 SRC_BDY_LVC1 sky130_fd_pr__nfet_01v8 ad=4.095 pd=8.17 as=7.875 ps=16.25 w=7 l=0.18
X151 SRC_BDY_LVC1 a_450_404# DRN_LVC1 SRC_BDY_LVC1 sky130_fd_pr__nfet_01v8 ad=5.625 pd=12.25 as=2.925 ps=6.17 w=5 l=0.18
X152 DRN_LVC2 a_2872_5340# SRC_BDY_LVC2 SRC_BDY_LVC2 sky130_fd_pr__nfet_01v8 ad=3.535 pd=8.01 as=3.5 ps=15 w=7 l=0.18
X153 SRC_BDY_LVC1 a_450_404# DRN_LVC1 SRC_BDY_LVC1 sky130_fd_pr__nfet_01v8 ad=7.875 pd=16.25 as=4.095 ps=8.17 w=7 l=0.18
X154 SRC_BDY_LVC1 a_450_404# DRN_LVC1 SRC_BDY_LVC1 sky130_fd_pr__nfet_01v8 ad=7.875 pd=16.25 as=4.095 ps=8.17 w=7 l=0.18
X155 DRN_LVC2 a_2872_5340# SRC_BDY_LVC2 SRC_BDY_LVC2 sky130_fd_pr__nfet_01v8 ad=3.535 pd=8.01 as=3.5 ps=15 w=7 l=0.18
X156 SRC_BDY_LVC2 a_2872_5340# DRN_LVC2 SRC_BDY_LVC2 sky130_fd_pr__nfet_01v8 ad=3.5 pd=15 as=3.535 ps=8.01 w=7 l=0.18
X157 DRN_LVC1 a_450_404# SRC_BDY_LVC1 SRC_BDY_LVC1 sky130_fd_pr__nfet_01v8 ad=4.095 pd=8.17 as=7.875 ps=16.25 w=7 l=0.18
X158 SRC_BDY_LVC1 a_414_306# SRC_BDY_LVC1 SRC_BDY_LVC1 sky130_fd_pr__nfet_01v8 ad=0.98 pd=7.28 as=0 ps=0 w=7 l=8
X159 DRN_LVC2 a_2872_5340# SRC_BDY_LVC2 SRC_BDY_LVC2 sky130_fd_pr__nfet_01v8 ad=3.535 pd=8.01 as=3.5 ps=15 w=7 l=0.18
X160 DRN_LVC1 a_450_404# SRC_BDY_LVC1 SRC_BDY_LVC1 sky130_fd_pr__nfet_01v8 ad=4.095 pd=8.17 as=7.875 ps=16.25 w=7 l=0.18
X161 DRN_LVC1 a_450_404# SRC_BDY_LVC1 SRC_BDY_LVC1 sky130_fd_pr__nfet_01v8 ad=4.095 pd=8.17 as=7.875 ps=16.25 w=7 l=0.18
X162 DRN_LVC2 a_2872_5340# SRC_BDY_LVC2 SRC_BDY_LVC2 sky130_fd_pr__nfet_01v8 ad=3.535 pd=8.01 as=3.5 ps=15 w=7 l=0.18
X163 SRC_BDY_LVC1 a_450_404# DRN_LVC1 SRC_BDY_LVC1 sky130_fd_pr__nfet_01v8 ad=3.5 pd=15 as=3.535 ps=8.01 w=7 l=0.18
X164 SRC_BDY_LVC2 a_2872_5340# DRN_LVC2 SRC_BDY_LVC2 sky130_fd_pr__nfet_01v8 ad=3.5 pd=15 as=3.535 ps=8.01 w=7 l=0.18
X165 DRN_LVC2 a_2872_5340# SRC_BDY_LVC2 SRC_BDY_LVC2 sky130_fd_pr__nfet_01v8 ad=3.535 pd=8.01 as=3.5 ps=15 w=7 l=0.18
X166 SRC_BDY_LVC2 a_2872_5340# DRN_LVC2 SRC_BDY_LVC2 sky130_fd_pr__nfet_01v8 ad=2.5 pd=11 as=2.525 ps=6.01 w=5 l=0.18
X167 DRN_LVC1 a_414_306# a_450_404# DRN_LVC1 sky130_fd_pr__pfet_01v8 ad=0.98 pd=7.28 as=0.98 ps=7.28 w=7 l=0.18
X168 DRN_LVC2 a_2872_5340# SRC_BDY_LVC2 SRC_BDY_LVC2 sky130_fd_pr__nfet_01v8 ad=3.535 pd=8.01 as=3.5 ps=15 w=7 l=0.18
X169 SRC_BDY_LVC1 a_450_404# DRN_LVC1 SRC_BDY_LVC1 sky130_fd_pr__nfet_01v8 ad=7.875 pd=16.25 as=4.095 ps=8.17 w=7 l=0.18
X170 SRC_BDY_LVC2 a_2872_5340# DRN_LVC2 SRC_BDY_LVC2 sky130_fd_pr__nfet_01v8 ad=3.5 pd=15 as=3.535 ps=8.01 w=7 l=0.18
X171 DRN_LVC1 a_450_404# SRC_BDY_LVC1 SRC_BDY_LVC1 sky130_fd_pr__nfet_01v8 ad=3.535 pd=8.01 as=3.5 ps=15 w=7 l=0.18
X172 DRN_LVC2 a_2595_15129# a_2872_5340# DRN_LVC2 sky130_fd_pr__pfet_01v8 ad=0.98 pd=7.28 as=0.98 ps=7.28 w=7 l=0.18
X173 SRC_BDY_LVC1 a_414_306# SRC_BDY_LVC1 SRC_BDY_LVC1 sky130_fd_pr__nfet_01v8 ad=0.98 pd=7.28 as=0 ps=0 w=7 l=8
X174 DRN_LVC1 a_450_404# SRC_BDY_LVC1 SRC_BDY_LVC1 sky130_fd_pr__nfet_01v8 ad=4.095 pd=8.17 as=7.875 ps=16.25 w=7 l=0.18
X175 a_450_404# a_414_306# DRN_LVC1 DRN_LVC1 sky130_fd_pr__pfet_01v8 ad=0.98 pd=7.28 as=0.98 ps=7.28 w=7 l=0.18
X176 SRC_BDY_LVC2 a_2872_5340# DRN_LVC2 SRC_BDY_LVC2 sky130_fd_pr__nfet_01v8 ad=2.5 pd=11 as=2.525 ps=6.01 w=5 l=0.18
X177 DRN_LVC2 a_2872_5340# SRC_BDY_LVC2 SRC_BDY_LVC2 sky130_fd_pr__nfet_01v8 ad=3.535 pd=8.01 as=3.5 ps=15 w=7 l=0.18
X178 DRN_LVC1 a_450_404# SRC_BDY_LVC1 SRC_BDY_LVC1 sky130_fd_pr__nfet_01v8 ad=3.535 pd=8.01 as=3.5 ps=15 w=7 l=0.18
X179 DRN_LVC1 a_450_404# SRC_BDY_LVC1 SRC_BDY_LVC1 sky130_fd_pr__nfet_01v8 ad=4.095 pd=8.17 as=7.875 ps=16.25 w=7 l=0.18
X180 SRC_BDY_LVC2 a_2872_5340# DRN_LVC2 SRC_BDY_LVC2 sky130_fd_pr__nfet_01v8 ad=3.5 pd=15 as=3.535 ps=8.01 w=7 l=0.18
X181 DRN_LVC1 a_414_306# a_450_404# DRN_LVC1 sky130_fd_pr__pfet_01v8 ad=0.98 pd=7.28 as=0.98 ps=7.28 w=7 l=0.18
X182 SRC_BDY_LVC1 a_450_404# DRN_LVC1 SRC_BDY_LVC1 sky130_fd_pr__nfet_01v8 ad=7.875 pd=16.25 as=4.095 ps=8.17 w=7 l=0.18
X183 DRN_LVC2 a_2872_5340# SRC_BDY_LVC2 SRC_BDY_LVC2 sky130_fd_pr__nfet_01v8 ad=3.535 pd=8.01 as=3.5 ps=15 w=7 l=0.18
X184 DRN_LVC2 a_2872_5340# SRC_BDY_LVC2 SRC_BDY_LVC2 sky130_fd_pr__nfet_01v8 ad=2.525 pd=6.01 as=2.5 ps=11 w=5 l=0.18
X185 DRN_LVC2 a_2872_5340# SRC_BDY_LVC2 SRC_BDY_LVC2 sky130_fd_pr__nfet_01v8 ad=3.535 pd=8.01 as=3.5 ps=15 w=7 l=0.18
X186 SRC_BDY_LVC2 a_2872_5340# DRN_LVC2 SRC_BDY_LVC2 sky130_fd_pr__nfet_01v8 ad=3.5 pd=15 as=3.535 ps=8.01 w=7 l=0.18
X187 SRC_BDY_LVC1 a_450_404# DRN_LVC1 SRC_BDY_LVC1 sky130_fd_pr__nfet_01v8 ad=7.875 pd=16.25 as=4.095 ps=8.17 w=7 l=0.18
X188 SRC_BDY_LVC1 a_414_306# SRC_BDY_LVC1 SRC_BDY_LVC1 sky130_fd_pr__nfet_01v8 ad=0.98 pd=7.28 as=0 ps=0 w=7 l=8
X189 DRN_LVC1 a_450_404# SRC_BDY_LVC1 SRC_BDY_LVC1 sky130_fd_pr__nfet_01v8 ad=3.535 pd=8.01 as=3.5 ps=15 w=7 l=0.18
X190 BDY2_B2B SRC_BDY_LVC1 sky130_fd_pr__diode_pd2nw_05v5 perim=3.3e+07 area=2.25e+13
X191 SRC_BDY_LVC1 a_450_404# DRN_LVC1 SRC_BDY_LVC1 sky130_fd_pr__nfet_01v8 ad=7.875 pd=16.25 as=4.095 ps=8.17 w=7 l=0.18
X192 DRN_LVC1 a_450_404# SRC_BDY_LVC1 SRC_BDY_LVC1 sky130_fd_pr__nfet_01v8 ad=3.535 pd=8.01 as=3.5 ps=15 w=7 l=0.18
X193 SRC_BDY_LVC2 a_2872_5340# DRN_LVC2 SRC_BDY_LVC2 sky130_fd_pr__nfet_01v8 ad=3.5 pd=15 as=3.535 ps=8.01 w=7 l=0.18
X194 SRC_BDY_LVC2 a_2595_15129# SRC_BDY_LVC2 SRC_BDY_LVC2 sky130_fd_pr__nfet_01v8 ad=0.98 pd=7.28 as=0 ps=0 w=7 l=8
X195 SRC_BDY_LVC1 a_450_404# DRN_LVC1 SRC_BDY_LVC1 sky130_fd_pr__nfet_01v8 ad=3.5 pd=15 as=3.535 ps=8.01 w=7 l=0.18
X196 DRN_LVC2 a_2872_5340# SRC_BDY_LVC2 SRC_BDY_LVC2 sky130_fd_pr__nfet_01v8 ad=3.535 pd=8.01 as=3.5 ps=15 w=7 l=0.18
X197 DRN_LVC1 a_450_404# SRC_BDY_LVC1 SRC_BDY_LVC1 sky130_fd_pr__nfet_01v8 ad=4.095 pd=8.17 as=7.875 ps=16.25 w=7 l=0.18
X198 DRN_LVC1 a_450_404# SRC_BDY_LVC1 SRC_BDY_LVC1 sky130_fd_pr__nfet_01v8 ad=3.535 pd=8.01 as=3.5 ps=15 w=7 l=0.18
X199 DRN_LVC2 a_2872_5340# SRC_BDY_LVC2 SRC_BDY_LVC2 sky130_fd_pr__nfet_01v8 ad=2.525 pd=6.01 as=2.5 ps=11 w=5 l=0.18
X200 SRC_BDY_LVC2 a_2872_5340# DRN_LVC2 SRC_BDY_LVC2 sky130_fd_pr__nfet_01v8 ad=3.5 pd=15 as=3.535 ps=8.01 w=7 l=0.18
X201 DRN_LVC2 a_2872_5340# SRC_BDY_LVC2 SRC_BDY_LVC2 sky130_fd_pr__nfet_01v8 ad=3.535 pd=8.01 as=3.5 ps=15 w=7 l=0.18
X202 SRC_BDY_LVC2 a_2872_5340# DRN_LVC2 SRC_BDY_LVC2 sky130_fd_pr__nfet_01v8 ad=3.5 pd=15 as=3.535 ps=8.01 w=7 l=0.18
X203 SRC_BDY_LVC2 a_2872_5340# DRN_LVC2 SRC_BDY_LVC2 sky130_fd_pr__nfet_01v8 ad=3.5 pd=15 as=3.535 ps=8.01 w=7 l=0.18
X204 DRN_LVC2 a_2872_5340# SRC_BDY_LVC2 SRC_BDY_LVC2 sky130_fd_pr__nfet_01v8 ad=2.525 pd=6.01 as=2.5 ps=11 w=5 l=0.18
X205 SRC_BDY_LVC1 a_450_404# DRN_LVC1 SRC_BDY_LVC1 sky130_fd_pr__nfet_01v8 ad=3.5 pd=15 as=3.535 ps=8.01 w=7 l=0.18
R0 G_CORE PADISOR sky130_fd_pr__res_generic_m3 w=11.825 l=10m
X206 SRC_BDY_LVC1 a_450_404# DRN_LVC1 SRC_BDY_LVC1 sky130_fd_pr__nfet_01v8 ad=7.875 pd=16.25 as=4.095 ps=8.17 w=7 l=0.18
X207 DRN_LVC1 a_450_404# SRC_BDY_LVC1 SRC_BDY_LVC1 sky130_fd_pr__nfet_01v8 ad=3.535 pd=8.01 as=3.5 ps=15 w=7 l=0.18
X208 DRN_LVC1 a_414_306# a_450_404# DRN_LVC1 sky130_fd_pr__pfet_01v8 ad=0.98 pd=7.28 as=0.98 ps=7.28 w=7 l=0.18
X209 DRN_LVC2 a_2872_5340# SRC_BDY_LVC2 SRC_BDY_LVC2 sky130_fd_pr__nfet_01v8 ad=2.525 pd=6.01 as=2.5 ps=11 w=5 l=0.18
X210 DRN_LVC1 a_450_404# SRC_BDY_LVC1 SRC_BDY_LVC1 sky130_fd_pr__nfet_01v8 ad=4.095 pd=8.17 as=7.875 ps=16.25 w=7 l=0.18
X211 SRC_BDY_LVC2 a_2595_15129# SRC_BDY_LVC2 SRC_BDY_LVC2 sky130_fd_pr__nfet_01v8 ad=0.7 pd=5.28 as=0 ps=0 w=5 l=8
X212 DRN_LVC2 a_2872_5340# SRC_BDY_LVC2 SRC_BDY_LVC2 sky130_fd_pr__nfet_01v8 ad=3.535 pd=8.01 as=3.5 ps=15 w=7 l=0.18
X213 SRC_BDY_LVC2 a_2872_5340# DRN_LVC2 SRC_BDY_LVC2 sky130_fd_pr__nfet_01v8 ad=3.5 pd=15 as=3.535 ps=8.01 w=7 l=0.18
X214 DRN_LVC1 a_450_404# SRC_BDY_LVC1 SRC_BDY_LVC1 sky130_fd_pr__nfet_01v8 ad=2.925 pd=6.17 as=5.625 ps=12.25 w=5 l=0.18
X215 SRC_BDY_LVC1 a_450_404# DRN_LVC1 SRC_BDY_LVC1 sky130_fd_pr__nfet_01v8 ad=3.5 pd=15 as=3.535 ps=8.01 w=7 l=0.18
X216 DRN_LVC1 a_414_306# a_450_404# DRN_LVC1 sky130_fd_pr__pfet_01v8 ad=1.96 pd=14.56 as=0.98 ps=7.28 w=7 l=0.18
X217 SRC_BDY_LVC2 a_2872_5340# DRN_LVC2 SRC_BDY_LVC2 sky130_fd_pr__nfet_01v8 ad=3.5 pd=15 as=3.535 ps=8.01 w=7 l=0.18
X218 SRC_BDY_LVC1 a_450_404# DRN_LVC1 SRC_BDY_LVC1 sky130_fd_pr__nfet_01v8 ad=3.5 pd=15 as=3.535 ps=8.01 w=7 l=0.18
X219 DRN_LVC1 a_450_404# SRC_BDY_LVC1 SRC_BDY_LVC1 sky130_fd_pr__nfet_01v8 ad=3.535 pd=8.01 as=3.5 ps=15 w=7 l=0.18
X220 SRC_BDY_LVC2 a_2872_5340# DRN_LVC2 SRC_BDY_LVC2 sky130_fd_pr__nfet_01v8 ad=3.5 pd=15 as=3.535 ps=8.01 w=7 l=0.18
X221 SRC_BDY_LVC1 a_450_404# DRN_LVC1 SRC_BDY_LVC1 sky130_fd_pr__nfet_01v8 ad=7.875 pd=16.25 as=4.095 ps=8.17 w=7 l=0.18
X222 SRC_BDY_LVC2 a_2872_5340# DRN_LVC2 SRC_BDY_LVC2 sky130_fd_pr__nfet_01v8 ad=2.5 pd=11 as=2.525 ps=6.01 w=5 l=0.18
X223 DRN_LVC2 a_2872_5340# SRC_BDY_LVC2 SRC_BDY_LVC2 sky130_fd_pr__nfet_01v8 ad=3.535 pd=8.01 as=3.5 ps=15 w=7 l=0.18
X224 DRN_LVC2 a_2872_5340# SRC_BDY_LVC2 SRC_BDY_LVC2 sky130_fd_pr__nfet_01v8 ad=3.535 pd=8.01 as=3.5 ps=15 w=7 l=0.18
X225 SRC_BDY_LVC1 a_414_306# SRC_BDY_LVC1 SRC_BDY_LVC1 sky130_fd_pr__nfet_01v8 ad=0.98 pd=7.28 as=0 ps=0 w=7 l=8
X226 SRC_BDY_LVC2 a_2872_5340# DRN_LVC2 SRC_BDY_LVC2 sky130_fd_pr__nfet_01v8 ad=3.5 pd=15 as=3.535 ps=8.01 w=7 l=0.18
R1 G_CORE PADISOL sky130_fd_pr__res_generic_m3 w=11.825 l=10m
X227 DRN_LVC2 a_2872_5340# SRC_BDY_LVC2 SRC_BDY_LVC2 sky130_fd_pr__nfet_01v8 ad=3.535 pd=8.01 as=3.5 ps=15 w=7 l=0.18
X228 DRN_LVC1 a_450_404# SRC_BDY_LVC1 SRC_BDY_LVC1 sky130_fd_pr__nfet_01v8 ad=3.535 pd=8.01 as=3.5 ps=15 w=7 l=0.18
X229 a_2872_5340# a_2595_15129# DRN_LVC2 DRN_LVC2 sky130_fd_pr__pfet_01v8 ad=0.98 pd=7.28 as=0.98 ps=7.28 w=7 l=0.18
X230 DRN_LVC1 a_450_404# SRC_BDY_LVC1 SRC_BDY_LVC1 sky130_fd_pr__nfet_01v8 ad=3.535 pd=8.01 as=3.5 ps=15 w=7 l=0.18
X231 DRN_LVC1 a_450_404# SRC_BDY_LVC1 SRC_BDY_LVC1 sky130_fd_pr__nfet_01v8 ad=3.535 pd=8.01 as=3.5 ps=15 w=7 l=0.18
X232 BDY2_B2B SRC_BDY_LVC1 sky130_fd_pr__diode_pd2nw_05v5 perim=3.3e+07 area=2.25e+13
X233 a_2872_5340# a_2595_15129# DRN_LVC2 DRN_LVC2 sky130_fd_pr__pfet_01v8 ad=0.98 pd=7.28 as=0.98 ps=7.28 w=7 l=0.18
X234 SRC_BDY_LVC1 a_450_404# DRN_LVC1 SRC_BDY_LVC1 sky130_fd_pr__nfet_01v8 ad=7.875 pd=16.25 as=4.095 ps=8.17 w=7 l=0.18
X235 SRC_BDY_LVC1 a_450_404# DRN_LVC1 SRC_BDY_LVC1 sky130_fd_pr__nfet_01v8 ad=3.5 pd=15 as=3.535 ps=8.01 w=7 l=0.18
X236 SRC_BDY_LVC2 a_2872_5340# DRN_LVC2 SRC_BDY_LVC2 sky130_fd_pr__nfet_01v8 ad=2.5 pd=11 as=2.525 ps=6.01 w=5 l=0.18
X237 DRN_LVC1 a_450_404# SRC_BDY_LVC1 SRC_BDY_LVC1 sky130_fd_pr__nfet_01v8 ad=3.535 pd=8.01 as=3.5 ps=15 w=7 l=0.18
X238 DRN_LVC2 a_2872_5340# SRC_BDY_LVC2 SRC_BDY_LVC2 sky130_fd_pr__nfet_01v8 ad=3.535 pd=8.01 as=3.5 ps=15 w=7 l=0.18
X239 DRN_LVC1 a_450_404# SRC_BDY_LVC1 SRC_BDY_LVC1 sky130_fd_pr__nfet_01v8 ad=4.095 pd=8.17 as=7.875 ps=16.25 w=7 l=0.18
X240 a_450_404# a_414_306# DRN_LVC1 DRN_LVC1 sky130_fd_pr__pfet_01v8 ad=0.98 pd=7.28 as=0.98 ps=7.28 w=7 l=0.18
X241 DRN_LVC2 a_2872_5340# SRC_BDY_LVC2 SRC_BDY_LVC2 sky130_fd_pr__nfet_01v8 ad=3.535 pd=8.01 as=3.5 ps=15 w=7 l=0.18
X242 SRC_BDY_LVC2 a_2872_5340# DRN_LVC2 SRC_BDY_LVC2 sky130_fd_pr__nfet_01v8 ad=3.5 pd=15 as=3.535 ps=8.01 w=7 l=0.18
X243 DRN_LVC1 a_450_404# SRC_BDY_LVC1 SRC_BDY_LVC1 sky130_fd_pr__nfet_01v8 ad=2.925 pd=6.17 as=5.625 ps=12.25 w=5 l=0.18
X244 a_450_404# a_414_306# DRN_LVC1 DRN_LVC1 sky130_fd_pr__pfet_01v8 ad=0.98 pd=7.28 as=0.98 ps=7.28 w=7 l=0.18
X245 SRC_BDY_LVC2 a_2872_5340# DRN_LVC2 SRC_BDY_LVC2 sky130_fd_pr__nfet_01v8 ad=2.5 pd=11 as=2.525 ps=6.01 w=5 l=0.18
X246 DRN_LVC2 a_2872_5340# SRC_BDY_LVC2 SRC_BDY_LVC2 sky130_fd_pr__nfet_01v8 ad=2.525 pd=6.01 as=2.5 ps=11 w=5 l=0.18
X247 DRN_LVC2 a_2872_5340# SRC_BDY_LVC2 SRC_BDY_LVC2 sky130_fd_pr__nfet_01v8 ad=3.535 pd=8.01 as=3.5 ps=15 w=7 l=0.18
X248 SRC_BDY_LVC1 a_450_404# DRN_LVC1 SRC_BDY_LVC1 sky130_fd_pr__nfet_01v8 ad=3.5 pd=15 as=3.535 ps=8.01 w=7 l=0.18
X249 SRC_BDY_LVC1 a_450_404# DRN_LVC1 SRC_BDY_LVC1 sky130_fd_pr__nfet_01v8 ad=7.875 pd=16.25 as=4.095 ps=8.17 w=7 l=0.18
X250 DRN_LVC2 a_2872_5340# SRC_BDY_LVC2 SRC_BDY_LVC2 sky130_fd_pr__nfet_01v8 ad=3.535 pd=8.01 as=3.5 ps=15 w=7 l=0.18
X251 DRN_LVC2 a_13955_3836# sky130_fd_pr__res_generic_po w=0.33 l=900
X252 DRN_LVC1 a_450_404# SRC_BDY_LVC1 SRC_BDY_LVC1 sky130_fd_pr__nfet_01v8 ad=4.095 pd=8.17 as=7.875 ps=16.25 w=7 l=0.18
X253 a_1871_4484# a_2183_16816# sky130_fd_pr__res_generic_po w=0.33 l=720
X254 DRN_LVC2 a_2872_5340# SRC_BDY_LVC2 SRC_BDY_LVC2 sky130_fd_pr__nfet_01v8 ad=3.535 pd=8.01 as=3.5 ps=15 w=7 l=0.18
X255 SRC_BDY_LVC1 a_450_404# DRN_LVC1 SRC_BDY_LVC1 sky130_fd_pr__nfet_01v8 ad=3.5 pd=15 as=3.535 ps=8.01 w=7 l=0.18
X256 DRN_LVC1 a_450_404# SRC_BDY_LVC1 SRC_BDY_LVC1 sky130_fd_pr__nfet_01v8 ad=4.095 pd=8.17 as=7.875 ps=16.25 w=7 l=0.18
X257 SRC_BDY_LVC2 a_2872_5340# DRN_LVC2 SRC_BDY_LVC2 sky130_fd_pr__nfet_01v8 ad=3.5 pd=15 as=3.535 ps=8.01 w=7 l=0.18
X258 SRC_BDY_LVC2 a_2872_5340# DRN_LVC2 SRC_BDY_LVC2 sky130_fd_pr__nfet_01v8 ad=3.5 pd=15 as=3.535 ps=8.01 w=7 l=0.18
X259 SRC_BDY_LVC1 a_450_404# DRN_LVC1 SRC_BDY_LVC1 sky130_fd_pr__nfet_01v8 ad=7.875 pd=16.25 as=4.095 ps=8.17 w=7 l=0.18
X260 DRN_LVC2 a_2872_5340# SRC_BDY_LVC2 SRC_BDY_LVC2 sky130_fd_pr__nfet_01v8 ad=3.535 pd=8.01 as=3.5 ps=15 w=7 l=0.18
X261 DRN_LVC2 a_2595_15129# a_2872_5340# DRN_LVC2 sky130_fd_pr__pfet_01v8 ad=1.96 pd=14.56 as=0.98 ps=7.28 w=7 l=0.18
X262 SRC_BDY_LVC2 a_2872_5340# DRN_LVC2 SRC_BDY_LVC2 sky130_fd_pr__nfet_01v8 ad=3.5 pd=15 as=3.535 ps=8.01 w=7 l=0.18
X263 SRC_BDY_LVC1 a_450_404# DRN_LVC1 SRC_BDY_LVC1 sky130_fd_pr__nfet_01v8 ad=7.875 pd=16.25 as=4.095 ps=8.17 w=7 l=0.18
X264 SRC_BDY_LVC2 a_2872_5340# DRN_LVC2 SRC_BDY_LVC2 sky130_fd_pr__nfet_01v8 ad=3.5 pd=15 as=3.535 ps=8.01 w=7 l=0.18
X265 DRN_LVC2 a_2872_5340# SRC_BDY_LVC2 SRC_BDY_LVC2 sky130_fd_pr__nfet_01v8 ad=3.535 pd=8.01 as=3.5 ps=15 w=7 l=0.18
X266 SRC_BDY_LVC1 a_450_404# DRN_LVC1 SRC_BDY_LVC1 sky130_fd_pr__nfet_01v8 ad=5.625 pd=12.25 as=2.925 ps=6.17 w=5 l=0.18
X267 DRN_LVC1 a_450_404# SRC_BDY_LVC1 SRC_BDY_LVC1 sky130_fd_pr__nfet_01v8 ad=3.535 pd=8.01 as=3.5 ps=15 w=7 l=0.18
X268 SRC_BDY_LVC1 a_450_404# DRN_LVC1 SRC_BDY_LVC1 sky130_fd_pr__nfet_01v8 ad=7.875 pd=16.25 as=4.095 ps=8.17 w=7 l=0.18
X269 SRC_BDY_LVC2 a_2872_5340# DRN_LVC2 SRC_BDY_LVC2 sky130_fd_pr__nfet_01v8 ad=3.5 pd=15 as=3.535 ps=8.01 w=7 l=0.18
X270 DRN_LVC1 a_450_404# SRC_BDY_LVC1 SRC_BDY_LVC1 sky130_fd_pr__nfet_01v8 ad=4.095 pd=8.17 as=7.875 ps=16.25 w=7 l=0.18
X271 a_2872_5340# a_2595_15129# DRN_LVC2 DRN_LVC2 sky130_fd_pr__pfet_01v8 ad=0.98 pd=7.28 as=0.98 ps=7.28 w=7 l=0.18
X272 SRC_BDY_LVC2 a_2872_5340# DRN_LVC2 SRC_BDY_LVC2 sky130_fd_pr__nfet_01v8 ad=3.5 pd=15 as=3.535 ps=8.01 w=7 l=0.18
X273 SRC_BDY_LVC1 a_450_404# DRN_LVC1 SRC_BDY_LVC1 sky130_fd_pr__nfet_01v8 ad=3.5 pd=15 as=3.535 ps=8.01 w=7 l=0.18
X274 SRC_BDY_LVC2 a_2595_15129# a_2872_5340# SRC_BDY_LVC2 sky130_fd_pr__nfet_01v8 ad=2.3975 pd=7.685 as=4.76 ps=15.36 w=7 l=0.18
X275 SRC_BDY_LVC2 a_2872_5340# DRN_LVC2 SRC_BDY_LVC2 sky130_fd_pr__nfet_01v8 ad=3.5 pd=15 as=3.535 ps=8.01 w=7 l=0.18
X276 DRN_LVC2 a_2872_5340# SRC_BDY_LVC2 SRC_BDY_LVC2 sky130_fd_pr__nfet_01v8 ad=3.535 pd=8.01 as=3.5 ps=15 w=7 l=0.18
X277 DRN_LVC2 a_2872_5340# SRC_BDY_LVC2 SRC_BDY_LVC2 sky130_fd_pr__nfet_01v8 ad=2.525 pd=6.01 as=2.5 ps=11 w=5 l=0.18
X278 DRN_LVC2 a_2872_5340# SRC_BDY_LVC2 SRC_BDY_LVC2 sky130_fd_pr__nfet_01v8 ad=3.535 pd=8.01 as=3.5 ps=15 w=7 l=0.18
X279 SRC_BDY_LVC1 a_414_306# SRC_BDY_LVC1 SRC_BDY_LVC1 sky130_fd_pr__nfet_01v8 ad=0.98 pd=7.28 as=0 ps=0 w=7 l=8
X280 SRC_BDY_LVC1 a_450_404# DRN_LVC1 SRC_BDY_LVC1 sky130_fd_pr__nfet_01v8 ad=7.875 pd=16.25 as=4.095 ps=8.17 w=7 l=0.18
X281 DRN_LVC2 a_2595_15129# a_2872_5340# DRN_LVC2 sky130_fd_pr__pfet_01v8 ad=0.98 pd=7.28 as=0.98 ps=7.28 w=7 l=0.18
X282 a_450_404# a_414_306# DRN_LVC1 DRN_LVC1 sky130_fd_pr__pfet_01v8 ad=0.98 pd=7.28 as=0.98 ps=7.28 w=7 l=0.18
X283 DRN_LVC2 a_2595_15129# a_2872_5340# DRN_LVC2 sky130_fd_pr__pfet_01v8 ad=0.98 pd=7.28 as=0.98 ps=7.28 w=7 l=0.18
X284 SRC_BDY_LVC1 a_450_404# DRN_LVC1 SRC_BDY_LVC1 sky130_fd_pr__nfet_01v8 ad=3.5 pd=15 as=3.535 ps=8.01 w=7 l=0.18
X285 SRC_BDY_LVC2 a_2595_15129# SRC_BDY_LVC2 SRC_BDY_LVC2 sky130_fd_pr__nfet_01v8 ad=2.3975 pd=7.685 as=0 ps=0 w=7 l=8
X286 SRC_BDY_LVC1 a_450_404# DRN_LVC1 SRC_BDY_LVC1 sky130_fd_pr__nfet_01v8 ad=5.625 pd=12.25 as=2.925 ps=6.17 w=5 l=0.18
X287 DRN_LVC1 a_450_404# SRC_BDY_LVC1 SRC_BDY_LVC1 sky130_fd_pr__nfet_01v8 ad=4.095 pd=8.17 as=7.875 ps=16.25 w=7 l=0.18
X288 SRC_BDY_LVC2 a_2872_5340# DRN_LVC2 SRC_BDY_LVC2 sky130_fd_pr__nfet_01v8 ad=3.5 pd=15 as=3.535 ps=8.01 w=7 l=0.18
X289 SRC_BDY_LVC2 a_2872_5340# DRN_LVC2 SRC_BDY_LVC2 sky130_fd_pr__nfet_01v8 ad=3.5 pd=15 as=3.535 ps=8.01 w=7 l=0.18
X290 SRC_BDY_LVC1 a_450_404# DRN_LVC1 SRC_BDY_LVC1 sky130_fd_pr__nfet_01v8 ad=7.875 pd=16.25 as=4.095 ps=8.17 w=7 l=0.18
X291 DRN_LVC1 a_450_404# SRC_BDY_LVC1 SRC_BDY_LVC1 sky130_fd_pr__nfet_01v8 ad=3.535 pd=8.01 as=3.5 ps=15 w=7 l=0.18
X292 SRC_BDY_LVC1 a_450_404# DRN_LVC1 SRC_BDY_LVC1 sky130_fd_pr__nfet_01v8 ad=7.875 pd=16.25 as=4.095 ps=8.17 w=7 l=0.18
X293 DRN_LVC2 a_2872_5340# SRC_BDY_LVC2 SRC_BDY_LVC2 sky130_fd_pr__nfet_01v8 ad=3.535 pd=8.01 as=3.5 ps=15 w=7 l=0.18
X294 DRN_LVC2 a_2595_15129# a_2872_5340# DRN_LVC2 sky130_fd_pr__pfet_01v8 ad=0.98 pd=7.28 as=0.98 ps=7.28 w=7 l=0.18
X295 SRC_BDY_LVC2 a_2872_5340# DRN_LVC2 SRC_BDY_LVC2 sky130_fd_pr__nfet_01v8 ad=2.5 pd=11 as=2.525 ps=6.01 w=5 l=0.18
X296 SRC_BDY_LVC1 BDY2_B2B sky130_fd_pr__diode_pd2nw_05v5 perim=3.3e+07 area=2.25e+13
X297 SRC_BDY_LVC1 a_450_404# DRN_LVC1 SRC_BDY_LVC1 sky130_fd_pr__nfet_01v8 ad=7.875 pd=16.25 as=4.095 ps=8.17 w=7 l=0.18
X298 DRN_LVC1 a_450_404# SRC_BDY_LVC1 SRC_BDY_LVC1 sky130_fd_pr__nfet_01v8 ad=3.535 pd=8.01 as=3.5 ps=15 w=7 l=0.18
X299 SRC_BDY_LVC2 a_2872_5340# DRN_LVC2 SRC_BDY_LVC2 sky130_fd_pr__nfet_01v8 ad=2.5 pd=11 as=2.525 ps=6.01 w=5 l=0.18
X300 SRC_BDY_LVC1 a_450_404# DRN_LVC1 SRC_BDY_LVC1 sky130_fd_pr__nfet_01v8 ad=3.5 pd=15 as=3.535 ps=8.01 w=7 l=0.18
X301 SRC_BDY_LVC2 a_2872_5340# DRN_LVC2 SRC_BDY_LVC2 sky130_fd_pr__nfet_01v8 ad=3.5 pd=15 as=3.535 ps=8.01 w=7 l=0.18
X302 DRN_LVC2 a_2872_5340# SRC_BDY_LVC2 SRC_BDY_LVC2 sky130_fd_pr__nfet_01v8 ad=3.535 pd=8.01 as=3.5 ps=15 w=7 l=0.18
X303 DRN_LVC1 a_450_404# SRC_BDY_LVC1 SRC_BDY_LVC1 sky130_fd_pr__nfet_01v8 ad=3.535 pd=8.01 as=3.5 ps=15 w=7 l=0.18
X304 DRN_LVC2 a_2872_5340# SRC_BDY_LVC2 SRC_BDY_LVC2 sky130_fd_pr__nfet_01v8 ad=3.535 pd=8.01 as=3.5 ps=15 w=7 l=0.18
X305 DRN_LVC1 a_450_404# SRC_BDY_LVC1 SRC_BDY_LVC1 sky130_fd_pr__nfet_01v8 ad=3.535 pd=8.01 as=3.5 ps=15 w=7 l=0.18
X306 DRN_LVC2 a_2872_5340# SRC_BDY_LVC2 SRC_BDY_LVC2 sky130_fd_pr__nfet_01v8 ad=2.525 pd=6.01 as=2.5 ps=11 w=5 l=0.18
X307 DRN_LVC1 a_450_404# SRC_BDY_LVC1 SRC_BDY_LVC1 sky130_fd_pr__nfet_01v8 ad=4.095 pd=8.17 as=7.875 ps=16.25 w=7 l=0.18
X308 SRC_BDY_LVC1 a_450_404# DRN_LVC1 SRC_BDY_LVC1 sky130_fd_pr__nfet_01v8 ad=7.875 pd=16.25 as=4.095 ps=8.17 w=7 l=0.18
X309 SRC_BDY_LVC1 a_450_404# DRN_LVC1 SRC_BDY_LVC1 sky130_fd_pr__nfet_01v8 ad=3.5 pd=15 as=3.535 ps=8.01 w=7 l=0.18
X310 SRC_BDY_LVC2 a_2595_15129# SRC_BDY_LVC2 SRC_BDY_LVC2 sky130_fd_pr__nfet_01v8 ad=0.98 pd=7.28 as=0 ps=0 w=7 l=8
X311 DRN_LVC1 a_450_404# SRC_BDY_LVC1 SRC_BDY_LVC1 sky130_fd_pr__nfet_01v8 ad=4.095 pd=8.17 as=7.875 ps=16.25 w=7 l=0.18
X312 SRC_BDY_LVC2 a_2872_5340# DRN_LVC2 SRC_BDY_LVC2 sky130_fd_pr__nfet_01v8 ad=3.5 pd=15 as=3.535 ps=8.01 w=7 l=0.18
X313 DRN_LVC2 a_2872_5340# SRC_BDY_LVC2 SRC_BDY_LVC2 sky130_fd_pr__nfet_01v8 ad=2.525 pd=6.01 as=2.5 ps=11 w=5 l=0.18
X314 SRC_BDY_LVC1 a_450_404# DRN_LVC1 SRC_BDY_LVC1 sky130_fd_pr__nfet_01v8 ad=3.5 pd=15 as=3.535 ps=8.01 w=7 l=0.18
X315 DRN_LVC1 a_450_404# SRC_BDY_LVC1 SRC_BDY_LVC1 sky130_fd_pr__nfet_01v8 ad=3.535 pd=8.01 as=3.5 ps=15 w=7 l=0.18
X316 SRC_BDY_LVC2 a_2595_15129# SRC_BDY_LVC2 SRC_BDY_LVC2 sky130_fd_pr__nfet_01v8 ad=0.7 pd=5.28 as=0 ps=0 w=5 l=8
X317 SRC_BDY_LVC2 a_2595_15129# SRC_BDY_LVC2 SRC_BDY_LVC2 sky130_fd_pr__nfet_01v8 ad=0.98 pd=7.28 as=0 ps=0 w=7 l=8
X318 SRC_BDY_LVC1 a_450_404# DRN_LVC1 SRC_BDY_LVC1 sky130_fd_pr__nfet_01v8 ad=5.625 pd=12.25 as=2.925 ps=6.17 w=5 l=0.18
X319 DRN_LVC1 a_414_306# a_450_404# DRN_LVC1 sky130_fd_pr__pfet_01v8 ad=1.96 pd=14.56 as=0.98 ps=7.28 w=7 l=0.18
X320 SRC_BDY_LVC2 a_2872_5340# DRN_LVC2 SRC_BDY_LVC2 sky130_fd_pr__nfet_01v8 ad=3.5 pd=15 as=3.535 ps=8.01 w=7 l=0.18
X321 DRN_LVC1 a_450_404# SRC_BDY_LVC1 SRC_BDY_LVC1 sky130_fd_pr__nfet_01v8 ad=4.095 pd=8.17 as=7.875 ps=16.25 w=7 l=0.18
X322 SRC_BDY_LVC1 a_414_306# a_450_404# SRC_BDY_LVC1 sky130_fd_pr__nfet_01v8 ad=2.3975 pd=7.685 as=4.76 ps=15.36 w=7 l=0.18
X323 a_2872_5340# a_2595_15129# DRN_LVC2 DRN_LVC2 sky130_fd_pr__pfet_01v8 ad=0.98 pd=7.28 as=1.96 ps=14.56 w=7 l=0.18
X324 SRC_BDY_LVC1 a_450_404# DRN_LVC1 SRC_BDY_LVC1 sky130_fd_pr__nfet_01v8 ad=3.5 pd=15 as=3.535 ps=8.01 w=7 l=0.18
X325 DRN_LVC2 a_2872_5340# SRC_BDY_LVC2 SRC_BDY_LVC2 sky130_fd_pr__nfet_01v8 ad=3.535 pd=8.01 as=3.5 ps=15 w=7 l=0.18
X326 DRN_LVC1 a_450_404# SRC_BDY_LVC1 SRC_BDY_LVC1 sky130_fd_pr__nfet_01v8 ad=3.535 pd=8.01 as=3.5 ps=15 w=7 l=0.18
X327 a_450_404# a_414_306# DRN_LVC1 DRN_LVC1 sky130_fd_pr__pfet_01v8 ad=0.98 pd=7.28 as=0.98 ps=7.28 w=7 l=0.18
X328 SRC_BDY_LVC2 a_2872_5340# DRN_LVC2 SRC_BDY_LVC2 sky130_fd_pr__nfet_01v8 ad=2.5 pd=11 as=2.525 ps=6.01 w=5 l=0.18
X329 DRN_LVC1 a_450_404# SRC_BDY_LVC1 SRC_BDY_LVC1 sky130_fd_pr__nfet_01v8 ad=2.925 pd=6.17 as=5.625 ps=12.25 w=5 l=0.18
X330 DRN_LVC2 a_2595_15129# a_2872_5340# DRN_LVC2 sky130_fd_pr__pfet_01v8 ad=1.96 pd=14.56 as=0.98 ps=7.28 w=7 l=0.18
X331 SRC_BDY_LVC2 a_2872_5340# DRN_LVC2 SRC_BDY_LVC2 sky130_fd_pr__nfet_01v8 ad=3.5 pd=15 as=3.535 ps=8.01 w=7 l=0.18
X332 DRN_LVC1 a_450_404# SRC_BDY_LVC1 SRC_BDY_LVC1 sky130_fd_pr__nfet_01v8 ad=4.095 pd=8.17 as=7.875 ps=16.25 w=7 l=0.18
X333 SRC_BDY_LVC2 a_2872_5340# DRN_LVC2 SRC_BDY_LVC2 sky130_fd_pr__nfet_01v8 ad=3.5 pd=15 as=3.535 ps=8.01 w=7 l=0.18
X334 DRN_LVC1 a_450_404# SRC_BDY_LVC1 SRC_BDY_LVC1 sky130_fd_pr__nfet_01v8 ad=3.535 pd=8.01 as=3.5 ps=15 w=7 l=0.18
X335 SRC_BDY_LVC1 a_450_404# DRN_LVC1 SRC_BDY_LVC1 sky130_fd_pr__nfet_01v8 ad=3.5 pd=15 as=3.535 ps=8.01 w=7 l=0.18
X336 DRN_LVC1 a_450_404# SRC_BDY_LVC1 SRC_BDY_LVC1 sky130_fd_pr__nfet_01v8 ad=3.535 pd=8.01 as=3.5 ps=15 w=7 l=0.18
X337 DRN_LVC2 a_2872_5340# SRC_BDY_LVC2 SRC_BDY_LVC2 sky130_fd_pr__nfet_01v8 ad=2.525 pd=6.01 as=2.5 ps=11 w=5 l=0.18
X338 DRN_LVC2 a_2872_5340# SRC_BDY_LVC2 SRC_BDY_LVC2 sky130_fd_pr__nfet_01v8 ad=3.535 pd=8.01 as=3.5 ps=15 w=7 l=0.18
X339 DRN_LVC1 a_450_404# SRC_BDY_LVC1 SRC_BDY_LVC1 sky130_fd_pr__nfet_01v8 ad=3.535 pd=8.01 as=3.5 ps=15 w=7 l=0.18
X340 SRC_BDY_LVC1 a_450_404# DRN_LVC1 SRC_BDY_LVC1 sky130_fd_pr__nfet_01v8 ad=7.875 pd=16.25 as=4.095 ps=8.17 w=7 l=0.18
X341 DRN_LVC1 a_450_404# SRC_BDY_LVC1 SRC_BDY_LVC1 sky130_fd_pr__nfet_01v8 ad=4.095 pd=8.17 as=7.875 ps=16.25 w=7 l=0.18
X342 DRN_LVC2 a_2872_5340# SRC_BDY_LVC2 SRC_BDY_LVC2 sky130_fd_pr__nfet_01v8 ad=3.535 pd=8.01 as=3.5 ps=15 w=7 l=0.18
X343 SRC_BDY_LVC1 a_450_404# DRN_LVC1 SRC_BDY_LVC1 sky130_fd_pr__nfet_01v8 ad=7.875 pd=16.25 as=4.095 ps=8.17 w=7 l=0.18
X344 SRC_BDY_LVC1 BDY2_B2B sky130_fd_pr__diode_pd2nw_05v5 perim=3.3e+07 area=2.25e+13
X345 SRC_BDY_LVC2 a_2872_5340# DRN_LVC2 SRC_BDY_LVC2 sky130_fd_pr__nfet_01v8 ad=2.5 pd=11 as=2.525 ps=6.01 w=5 l=0.18
X346 SRC_BDY_LVC1 a_450_404# DRN_LVC1 SRC_BDY_LVC1 sky130_fd_pr__nfet_01v8 ad=5.625 pd=12.25 as=2.925 ps=6.17 w=5 l=0.18
X347 DRN_LVC2 a_2872_5340# SRC_BDY_LVC2 SRC_BDY_LVC2 sky130_fd_pr__nfet_01v8 ad=3.535 pd=8.01 as=3.5 ps=15 w=7 l=0.18
X348 SRC_BDY_LVC2 a_2872_5340# DRN_LVC2 SRC_BDY_LVC2 sky130_fd_pr__nfet_01v8 ad=2.5 pd=11 as=2.525 ps=6.01 w=5 l=0.18
X349 DRN_LVC2 a_2872_5340# SRC_BDY_LVC2 SRC_BDY_LVC2 sky130_fd_pr__nfet_01v8 ad=3.535 pd=8.01 as=3.5 ps=15 w=7 l=0.18
X350 SRC_BDY_LVC1 a_450_404# DRN_LVC1 SRC_BDY_LVC1 sky130_fd_pr__nfet_01v8 ad=3.5 pd=15 as=3.535 ps=8.01 w=7 l=0.18
X351 SRC_BDY_LVC1 a_450_404# DRN_LVC1 SRC_BDY_LVC1 sky130_fd_pr__nfet_01v8 ad=7.875 pd=16.25 as=4.095 ps=8.17 w=7 l=0.18
X352 SRC_BDY_LVC1 a_414_306# a_450_404# SRC_BDY_LVC1 sky130_fd_pr__nfet_01v8 ad=2.3975 pd=7.685 as=4.76 ps=15.36 w=7 l=0.18
X353 SRC_BDY_LVC1 a_414_306# SRC_BDY_LVC1 SRC_BDY_LVC1 sky130_fd_pr__nfet_01v8 ad=2.3975 pd=7.685 as=0 ps=0 w=7 l=8
X354 SRC_BDY_LVC2 a_2595_15129# SRC_BDY_LVC2 SRC_BDY_LVC2 sky130_fd_pr__nfet_01v8 ad=0.98 pd=7.28 as=0 ps=0 w=7 l=8
X355 DRN_LVC1 a_414_306# a_450_404# DRN_LVC1 sky130_fd_pr__pfet_01v8 ad=0.98 pd=7.28 as=0.98 ps=7.28 w=7 l=0.18
X356 SRC_BDY_LVC1 a_450_404# DRN_LVC1 SRC_BDY_LVC1 sky130_fd_pr__nfet_01v8 ad=3.5 pd=15 as=3.535 ps=8.01 w=7 l=0.18
X357 DRN_LVC2 a_2872_5340# SRC_BDY_LVC2 SRC_BDY_LVC2 sky130_fd_pr__nfet_01v8 ad=3.535 pd=8.01 as=3.5 ps=15 w=7 l=0.18
X358 SRC_BDY_LVC2 a_2872_5340# DRN_LVC2 SRC_BDY_LVC2 sky130_fd_pr__nfet_01v8 ad=3.5 pd=15 as=3.535 ps=8.01 w=7 l=0.18
X359 SRC_BDY_LVC2 a_2872_5340# DRN_LVC2 SRC_BDY_LVC2 sky130_fd_pr__nfet_01v8 ad=3.5 pd=15 as=3.535 ps=8.01 w=7 l=0.18
X360 SRC_BDY_LVC2 a_2872_5340# DRN_LVC2 SRC_BDY_LVC2 sky130_fd_pr__nfet_01v8 ad=3.5 pd=15 as=3.535 ps=8.01 w=7 l=0.18
X361 DRN_LVC1 a_450_404# SRC_BDY_LVC1 SRC_BDY_LVC1 sky130_fd_pr__nfet_01v8 ad=4.095 pd=8.17 as=7.875 ps=16.25 w=7 l=0.18
X362 SRC_BDY_LVC1 a_450_404# DRN_LVC1 SRC_BDY_LVC1 sky130_fd_pr__nfet_01v8 ad=7.875 pd=16.25 as=4.095 ps=8.17 w=7 l=0.18
X363 DRN_LVC1 a_450_404# SRC_BDY_LVC1 SRC_BDY_LVC1 sky130_fd_pr__nfet_01v8 ad=3.535 pd=8.01 as=3.5 ps=15 w=7 l=0.18
X364 DRN_LVC1 a_450_404# SRC_BDY_LVC1 SRC_BDY_LVC1 sky130_fd_pr__nfet_01v8 ad=3.535 pd=8.01 as=3.5 ps=15 w=7 l=0.18
X365 SRC_BDY_LVC1 a_450_404# DRN_LVC1 SRC_BDY_LVC1 sky130_fd_pr__nfet_01v8 ad=3.5 pd=15 as=3.535 ps=8.01 w=7 l=0.18
X366 DRN_LVC2 a_2872_5340# SRC_BDY_LVC2 SRC_BDY_LVC2 sky130_fd_pr__nfet_01v8 ad=3.535 pd=8.01 as=3.5 ps=15 w=7 l=0.18
X367 SRC_BDY_LVC1 a_450_404# DRN_LVC1 SRC_BDY_LVC1 sky130_fd_pr__nfet_01v8 ad=7.875 pd=16.25 as=4.095 ps=8.17 w=7 l=0.18
X368 DRN_LVC1 a_450_404# SRC_BDY_LVC1 SRC_BDY_LVC1 sky130_fd_pr__nfet_01v8 ad=4.095 pd=8.17 as=7.875 ps=16.25 w=7 l=0.18
X369 SRC_BDY_LVC1 a_450_404# DRN_LVC1 SRC_BDY_LVC1 sky130_fd_pr__nfet_01v8 ad=7.875 pd=16.25 as=4.095 ps=8.17 w=7 l=0.18
X370 SRC_BDY_LVC2 a_2872_5340# DRN_LVC2 SRC_BDY_LVC2 sky130_fd_pr__nfet_01v8 ad=3.5 pd=15 as=3.535 ps=8.01 w=7 l=0.18
X371 SRC_BDY_LVC1 BDY2_B2B sky130_fd_pr__diode_pd2nw_05v5 perim=3.3e+07 area=2.25e+13
X372 SRC_BDY_LVC2 a_2872_5340# DRN_LVC2 SRC_BDY_LVC2 sky130_fd_pr__nfet_01v8 ad=3.5 pd=15 as=3.535 ps=8.01 w=7 l=0.18
X373 a_450_404# a_414_306# DRN_LVC1 DRN_LVC1 sky130_fd_pr__pfet_01v8 ad=0.98 pd=7.28 as=1.96 ps=14.56 w=7 l=0.18
X374 DRN_LVC2 a_2872_5340# SRC_BDY_LVC2 SRC_BDY_LVC2 sky130_fd_pr__nfet_01v8 ad=3.535 pd=8.01 as=3.5 ps=15 w=7 l=0.18
X375 SRC_BDY_LVC1 a_414_306# SRC_BDY_LVC1 SRC_BDY_LVC1 sky130_fd_pr__nfet_01v8 ad=0.98 pd=7.28 as=0 ps=0 w=7 l=8
X376 SRC_BDY_LVC2 a_2872_5340# DRN_LVC2 SRC_BDY_LVC2 sky130_fd_pr__nfet_01v8 ad=3.5 pd=15 as=3.535 ps=8.01 w=7 l=0.18
X377 DRN_LVC2 a_2872_5340# SRC_BDY_LVC2 SRC_BDY_LVC2 sky130_fd_pr__nfet_01v8 ad=2.525 pd=6.01 as=2.5 ps=11 w=5 l=0.18
X378 DRN_LVC1 a_450_404# SRC_BDY_LVC1 SRC_BDY_LVC1 sky130_fd_pr__nfet_01v8 ad=4.095 pd=8.17 as=7.875 ps=16.25 w=7 l=0.18
X379 SRC_BDY_LVC1 a_450_404# DRN_LVC1 SRC_BDY_LVC1 sky130_fd_pr__nfet_01v8 ad=7.875 pd=16.25 as=4.095 ps=8.17 w=7 l=0.18
X380 SRC_BDY_LVC1 a_414_306# SRC_BDY_LVC1 SRC_BDY_LVC1 sky130_fd_pr__nfet_01v8 ad=0.98 pd=7.28 as=0 ps=0 w=7 l=8
X381 SRC_BDY_LVC1 a_450_404# DRN_LVC1 SRC_BDY_LVC1 sky130_fd_pr__nfet_01v8 ad=3.5 pd=15 as=3.535 ps=8.01 w=7 l=0.18
X382 SRC_BDY_LVC2 a_2872_5340# DRN_LVC2 SRC_BDY_LVC2 sky130_fd_pr__nfet_01v8 ad=3.5 pd=15 as=3.535 ps=8.01 w=7 l=0.18
X383 DRN_LVC2 a_2872_5340# SRC_BDY_LVC2 SRC_BDY_LVC2 sky130_fd_pr__nfet_01v8 ad=3.535 pd=8.01 as=3.5 ps=15 w=7 l=0.18
X384 SRC_BDY_LVC1 a_450_404# DRN_LVC1 SRC_BDY_LVC1 sky130_fd_pr__nfet_01v8 ad=5.625 pd=12.25 as=2.925 ps=6.17 w=5 l=0.18
X385 SRC_BDY_LVC1 a_450_404# DRN_LVC1 SRC_BDY_LVC1 sky130_fd_pr__nfet_01v8 ad=3.5 pd=15 as=3.535 ps=8.01 w=7 l=0.18
X386 SRC_BDY_LVC2 a_2872_5340# DRN_LVC2 SRC_BDY_LVC2 sky130_fd_pr__nfet_01v8 ad=3.5 pd=15 as=3.535 ps=8.01 w=7 l=0.18
X387 DRN_LVC2 a_2872_5340# SRC_BDY_LVC2 SRC_BDY_LVC2 sky130_fd_pr__nfet_01v8 ad=3.535 pd=8.01 as=3.5 ps=15 w=7 l=0.18
X388 SRC_BDY_LVC2 a_2872_5340# DRN_LVC2 SRC_BDY_LVC2 sky130_fd_pr__nfet_01v8 ad=2.5 pd=11 as=2.525 ps=6.01 w=5 l=0.18
X389 SRC_BDY_LVC2 a_2595_15129# SRC_BDY_LVC2 SRC_BDY_LVC2 sky130_fd_pr__nfet_01v8 ad=0.7 pd=5.28 as=0 ps=0 w=5 l=8
X390 DRN_LVC2 a_2872_5340# SRC_BDY_LVC2 SRC_BDY_LVC2 sky130_fd_pr__nfet_01v8 ad=3.535 pd=8.01 as=3.5 ps=15 w=7 l=0.18
X391 SRC_BDY_LVC1 a_450_404# DRN_LVC1 SRC_BDY_LVC1 sky130_fd_pr__nfet_01v8 ad=7.875 pd=16.25 as=4.095 ps=8.17 w=7 l=0.18
X392 DRN_LVC1 a_450_404# SRC_BDY_LVC1 SRC_BDY_LVC1 sky130_fd_pr__nfet_01v8 ad=4.095 pd=8.17 as=7.875 ps=16.25 w=7 l=0.18
X393 DRN_LVC1 a_450_404# SRC_BDY_LVC1 SRC_BDY_LVC1 sky130_fd_pr__nfet_01v8 ad=3.535 pd=8.01 as=3.5 ps=15 w=7 l=0.18
X394 SRC_BDY_LVC1 a_450_404# DRN_LVC1 SRC_BDY_LVC1 sky130_fd_pr__nfet_01v8 ad=7.875 pd=16.25 as=4.095 ps=8.17 w=7 l=0.18
X395 SRC_BDY_LVC2 a_2872_5340# DRN_LVC2 SRC_BDY_LVC2 sky130_fd_pr__nfet_01v8 ad=3.5 pd=15 as=3.535 ps=8.01 w=7 l=0.18
X396 SRC_BDY_LVC1 a_414_306# SRC_BDY_LVC1 SRC_BDY_LVC1 sky130_fd_pr__nfet_01v8 ad=0.98 pd=7.28 as=0 ps=0 w=7 l=8
X397 SRC_BDY_LVC2 a_2872_5340# DRN_LVC2 SRC_BDY_LVC2 sky130_fd_pr__nfet_01v8 ad=2.5 pd=11 as=2.525 ps=6.01 w=5 l=0.18
X398 DRN_LVC1 a_450_404# SRC_BDY_LVC1 SRC_BDY_LVC1 sky130_fd_pr__nfet_01v8 ad=4.095 pd=8.17 as=7.875 ps=16.25 w=7 l=0.18
X399 DRN_LVC2 a_2872_5340# SRC_BDY_LVC2 SRC_BDY_LVC2 sky130_fd_pr__nfet_01v8 ad=3.535 pd=8.01 as=3.5 ps=15 w=7 l=0.18
X400 DRN_LVC2 a_2872_5340# SRC_BDY_LVC2 SRC_BDY_LVC2 sky130_fd_pr__nfet_01v8 ad=3.535 pd=8.01 as=3.5 ps=15 w=7 l=0.18
X401 DRN_LVC1 a_450_404# SRC_BDY_LVC1 SRC_BDY_LVC1 sky130_fd_pr__nfet_01v8 ad=3.535 pd=8.01 as=3.5 ps=15 w=7 l=0.18
X402 a_2872_5340# a_2595_15129# DRN_LVC2 DRN_LVC2 sky130_fd_pr__pfet_01v8 ad=0.98 pd=7.28 as=0.98 ps=7.28 w=7 l=0.18
X403 a_2872_5340# a_2595_15129# DRN_LVC2 DRN_LVC2 sky130_fd_pr__pfet_01v8 ad=0.98 pd=7.28 as=0.98 ps=7.28 w=7 l=0.18
X404 DRN_LVC1 a_450_404# SRC_BDY_LVC1 SRC_BDY_LVC1 sky130_fd_pr__nfet_01v8 ad=4.095 pd=8.17 as=7.875 ps=16.25 w=7 l=0.18
X405 SRC_BDY_LVC1 a_450_404# DRN_LVC1 SRC_BDY_LVC1 sky130_fd_pr__nfet_01v8 ad=7.875 pd=16.25 as=4.095 ps=8.17 w=7 l=0.18
X406 SRC_BDY_LVC1 a_450_404# DRN_LVC1 SRC_BDY_LVC1 sky130_fd_pr__nfet_01v8 ad=3.5 pd=15 as=3.535 ps=8.01 w=7 l=0.18
X407 SRC_BDY_LVC1 a_450_404# DRN_LVC1 SRC_BDY_LVC1 sky130_fd_pr__nfet_01v8 ad=5.625 pd=12.25 as=2.925 ps=6.17 w=5 l=0.18
X408 SRC_BDY_LVC2 a_2872_5340# DRN_LVC2 SRC_BDY_LVC2 sky130_fd_pr__nfet_01v8 ad=3.5 pd=15 as=3.535 ps=8.01 w=7 l=0.18
X409 DRN_LVC1 a_450_404# SRC_BDY_LVC1 SRC_BDY_LVC1 sky130_fd_pr__nfet_01v8 ad=4.095 pd=8.17 as=7.875 ps=16.25 w=7 l=0.18
X410 a_450_404# a_414_306# DRN_LVC1 DRN_LVC1 sky130_fd_pr__pfet_01v8 ad=0.98 pd=7.28 as=0.98 ps=7.28 w=7 l=0.18
X411 a_2872_5340# a_2595_15129# DRN_LVC2 DRN_LVC2 sky130_fd_pr__pfet_01v8 ad=0.98 pd=7.28 as=0.98 ps=7.28 w=7 l=0.18
X412 SRC_BDY_LVC2 a_2872_5340# DRN_LVC2 SRC_BDY_LVC2 sky130_fd_pr__nfet_01v8 ad=3.5 pd=15 as=3.535 ps=8.01 w=7 l=0.18
X413 DRN_LVC1 a_450_404# SRC_BDY_LVC1 SRC_BDY_LVC1 sky130_fd_pr__nfet_01v8 ad=4.095 pd=8.17 as=7.875 ps=16.25 w=7 l=0.18
X414 SRC_BDY_LVC1 a_450_404# DRN_LVC1 SRC_BDY_LVC1 sky130_fd_pr__nfet_01v8 ad=3.5 pd=15 as=3.535 ps=8.01 w=7 l=0.18
X415 SRC_BDY_LVC1 a_450_404# DRN_LVC1 SRC_BDY_LVC1 sky130_fd_pr__nfet_01v8 ad=3.5 pd=15 as=3.535 ps=8.01 w=7 l=0.18
X416 SRC_BDY_LVC2 a_2872_5340# DRN_LVC2 SRC_BDY_LVC2 sky130_fd_pr__nfet_01v8 ad=3.5 pd=15 as=3.535 ps=8.01 w=7 l=0.18
X417 DRN_LVC2 a_2872_5340# SRC_BDY_LVC2 SRC_BDY_LVC2 sky130_fd_pr__nfet_01v8 ad=3.535 pd=8.01 as=3.5 ps=15 w=7 l=0.18
X418 SRC_BDY_LVC2 a_2872_5340# DRN_LVC2 SRC_BDY_LVC2 sky130_fd_pr__nfet_01v8 ad=3.5 pd=15 as=3.535 ps=8.01 w=7 l=0.18
X419 SRC_BDY_LVC2 a_2595_15129# SRC_BDY_LVC2 SRC_BDY_LVC2 sky130_fd_pr__nfet_01v8 ad=0.98 pd=7.28 as=0 ps=0 w=7 l=8
X420 SRC_BDY_LVC1 a_414_306# SRC_BDY_LVC1 SRC_BDY_LVC1 sky130_fd_pr__nfet_01v8 ad=0.98 pd=7.28 as=0 ps=0 w=7 l=8
X421 DRN_LVC1 a_450_404# SRC_BDY_LVC1 SRC_BDY_LVC1 sky130_fd_pr__nfet_01v8 ad=3.535 pd=8.01 as=3.5 ps=15 w=7 l=0.18
X422 DRN_LVC2 a_2872_5340# SRC_BDY_LVC2 SRC_BDY_LVC2 sky130_fd_pr__nfet_01v8 ad=3.535 pd=8.01 as=3.5 ps=15 w=7 l=0.18
X423 SRC_BDY_LVC2 a_2872_5340# DRN_LVC2 SRC_BDY_LVC2 sky130_fd_pr__nfet_01v8 ad=3.5 pd=15 as=3.535 ps=8.01 w=7 l=0.18
X424 DRN_LVC2 a_2872_5340# SRC_BDY_LVC2 SRC_BDY_LVC2 sky130_fd_pr__nfet_01v8 ad=2.525 pd=6.01 as=2.5 ps=11 w=5 l=0.18
X425 SRC_BDY_LVC2 a_2595_15129# SRC_BDY_LVC2 SRC_BDY_LVC2 sky130_fd_pr__nfet_01v8 ad=0.7 pd=5.28 as=0 ps=0 w=5 l=8
X426 SRC_BDY_LVC1 a_450_404# DRN_LVC1 SRC_BDY_LVC1 sky130_fd_pr__nfet_01v8 ad=7.875 pd=16.25 as=4.095 ps=8.17 w=7 l=0.18
X427 SRC_BDY_LVC1 a_450_404# DRN_LVC1 SRC_BDY_LVC1 sky130_fd_pr__nfet_01v8 ad=7.875 pd=16.25 as=4.095 ps=8.17 w=7 l=0.18
X428 DRN_LVC1 a_450_404# SRC_BDY_LVC1 SRC_BDY_LVC1 sky130_fd_pr__nfet_01v8 ad=3.535 pd=8.01 as=3.5 ps=15 w=7 l=0.18
X429 SRC_BDY_LVC2 a_2872_5340# DRN_LVC2 SRC_BDY_LVC2 sky130_fd_pr__nfet_01v8 ad=3.5 pd=15 as=3.535 ps=8.01 w=7 l=0.18
X430 SRC_BDY_LVC1 a_450_404# DRN_LVC1 SRC_BDY_LVC1 sky130_fd_pr__nfet_01v8 ad=7.875 pd=16.25 as=4.095 ps=8.17 w=7 l=0.18
X431 SRC_BDY_LVC2 a_2872_5340# DRN_LVC2 SRC_BDY_LVC2 sky130_fd_pr__nfet_01v8 ad=3.5 pd=15 as=3.535 ps=8.01 w=7 l=0.18
X432 SRC_BDY_LVC1 a_450_404# DRN_LVC1 SRC_BDY_LVC1 sky130_fd_pr__nfet_01v8 ad=3.5 pd=15 as=3.535 ps=8.01 w=7 l=0.18
X433 DRN_LVC1 a_450_404# SRC_BDY_LVC1 SRC_BDY_LVC1 sky130_fd_pr__nfet_01v8 ad=4.095 pd=8.17 as=7.875 ps=16.25 w=7 l=0.18
X434 DRN_LVC1 a_450_404# SRC_BDY_LVC1 SRC_BDY_LVC1 sky130_fd_pr__nfet_01v8 ad=4.095 pd=8.17 as=7.875 ps=16.25 w=7 l=0.18
X435 DRN_LVC1 a_414_306# a_450_404# DRN_LVC1 sky130_fd_pr__pfet_01v8 ad=0.98 pd=7.28 as=0.98 ps=7.28 w=7 l=0.18
X436 SRC_BDY_LVC2 a_2872_5340# DRN_LVC2 SRC_BDY_LVC2 sky130_fd_pr__nfet_01v8 ad=3.5 pd=15 as=3.535 ps=8.01 w=7 l=0.18
X437 SRC_BDY_LVC1 a_450_404# DRN_LVC1 SRC_BDY_LVC1 sky130_fd_pr__nfet_01v8 ad=3.5 pd=15 as=3.535 ps=8.01 w=7 l=0.18
X438 DRN_LVC1 a_450_404# SRC_BDY_LVC1 SRC_BDY_LVC1 sky130_fd_pr__nfet_01v8 ad=3.535 pd=8.01 as=3.5 ps=15 w=7 l=0.18
X439 DRN_LVC2 a_2872_5340# SRC_BDY_LVC2 SRC_BDY_LVC2 sky130_fd_pr__nfet_01v8 ad=2.525 pd=6.01 as=2.5 ps=11 w=5 l=0.18
X440 BDY2_B2B SRC_BDY_LVC1 sky130_fd_pr__diode_pd2nw_05v5 perim=3.3e+07 area=2.25e+13
X441 DRN_LVC2 a_2872_5340# SRC_BDY_LVC2 SRC_BDY_LVC2 sky130_fd_pr__nfet_01v8 ad=3.535 pd=8.01 as=3.5 ps=15 w=7 l=0.18
X442 SRC_BDY_LVC1 a_450_404# DRN_LVC1 SRC_BDY_LVC1 sky130_fd_pr__nfet_01v8 ad=7.875 pd=16.25 as=4.095 ps=8.17 w=7 l=0.18
X443 DRN_LVC2 a_2872_5340# SRC_BDY_LVC2 SRC_BDY_LVC2 sky130_fd_pr__nfet_01v8 ad=3.535 pd=8.01 as=3.5 ps=15 w=7 l=0.18
X444 SRC_BDY_LVC2 a_2595_15129# SRC_BDY_LVC2 SRC_BDY_LVC2 sky130_fd_pr__nfet_01v8 ad=1.325 pd=10.53 as=0 ps=0 w=5 l=4
X445 SRC_BDY_LVC2 a_2872_5340# DRN_LVC2 SRC_BDY_LVC2 sky130_fd_pr__nfet_01v8 ad=3.5 pd=15 as=3.535 ps=8.01 w=7 l=0.18
X446 SRC_BDY_LVC2 a_2872_5340# DRN_LVC2 SRC_BDY_LVC2 sky130_fd_pr__nfet_01v8 ad=2.5 pd=11 as=2.525 ps=6.01 w=5 l=0.18
X447 DRN_LVC1 a_450_404# SRC_BDY_LVC1 SRC_BDY_LVC1 sky130_fd_pr__nfet_01v8 ad=4.095 pd=8.17 as=7.875 ps=16.25 w=7 l=0.18
X448 DRN_LVC1 a_450_404# SRC_BDY_LVC1 SRC_BDY_LVC1 sky130_fd_pr__nfet_01v8 ad=2.925 pd=6.17 as=5.625 ps=12.25 w=5 l=0.18
X449 SRC_BDY_LVC2 a_2872_5340# DRN_LVC2 SRC_BDY_LVC2 sky130_fd_pr__nfet_01v8 ad=3.5 pd=15 as=3.535 ps=8.01 w=7 l=0.18
X450 DRN_LVC1 a_450_404# SRC_BDY_LVC1 SRC_BDY_LVC1 sky130_fd_pr__nfet_01v8 ad=4.095 pd=8.17 as=7.875 ps=16.25 w=7 l=0.18
X451 SRC_BDY_LVC1 a_450_404# DRN_LVC1 SRC_BDY_LVC1 sky130_fd_pr__nfet_01v8 ad=3.5 pd=15 as=3.535 ps=8.01 w=7 l=0.18
X452 DRN_LVC2 a_2872_5340# SRC_BDY_LVC2 SRC_BDY_LVC2 sky130_fd_pr__nfet_01v8 ad=3.535 pd=8.01 as=3.5 ps=15 w=7 l=0.18
X453 SRC_BDY_LVC2 a_2872_5340# DRN_LVC2 SRC_BDY_LVC2 sky130_fd_pr__nfet_01v8 ad=3.5 pd=15 as=3.535 ps=8.01 w=7 l=0.18
X454 SRC_BDY_LVC1 a_450_404# DRN_LVC1 SRC_BDY_LVC1 sky130_fd_pr__nfet_01v8 ad=7.875 pd=16.25 as=4.095 ps=8.17 w=7 l=0.18
X455 DRN_LVC1 a_450_404# SRC_BDY_LVC1 SRC_BDY_LVC1 sky130_fd_pr__nfet_01v8 ad=2.925 pd=6.17 as=5.625 ps=12.25 w=5 l=0.18
X456 DRN_LVC2 a_2872_5340# SRC_BDY_LVC2 SRC_BDY_LVC2 sky130_fd_pr__nfet_01v8 ad=3.535 pd=8.01 as=3.5 ps=15 w=7 l=0.18
X457 DRN_LVC1 a_450_404# SRC_BDY_LVC1 SRC_BDY_LVC1 sky130_fd_pr__nfet_01v8 ad=3.535 pd=8.01 as=3.5 ps=15 w=7 l=0.18
X458 DRN_LVC2 a_2872_5340# SRC_BDY_LVC2 SRC_BDY_LVC2 sky130_fd_pr__nfet_01v8 ad=3.535 pd=8.01 as=3.5 ps=15 w=7 l=0.18
X459 SRC_BDY_LVC2 a_2872_5340# DRN_LVC2 SRC_BDY_LVC2 sky130_fd_pr__nfet_01v8 ad=2.5 pd=11 as=2.525 ps=6.01 w=5 l=0.18
X460 SRC_BDY_LVC1 a_450_404# DRN_LVC1 SRC_BDY_LVC1 sky130_fd_pr__nfet_01v8 ad=7.875 pd=16.25 as=4.095 ps=8.17 w=7 l=0.18
X461 SRC_BDY_LVC1 a_450_404# DRN_LVC1 SRC_BDY_LVC1 sky130_fd_pr__nfet_01v8 ad=7.875 pd=16.25 as=4.095 ps=8.17 w=7 l=0.18
X462 DRN_LVC2 a_2595_15129# a_2872_5340# DRN_LVC2 sky130_fd_pr__pfet_01v8 ad=0.98 pd=7.28 as=0.98 ps=7.28 w=7 l=0.18
X463 DRN_LVC2 a_2872_5340# SRC_BDY_LVC2 SRC_BDY_LVC2 sky130_fd_pr__nfet_01v8 ad=2.525 pd=6.01 as=2.5 ps=11 w=5 l=0.18
X464 SRC_BDY_LVC1 a_450_404# DRN_LVC1 SRC_BDY_LVC1 sky130_fd_pr__nfet_01v8 ad=3.5 pd=15 as=3.535 ps=8.01 w=7 l=0.18
X465 DRN_LVC1 a_450_404# SRC_BDY_LVC1 SRC_BDY_LVC1 sky130_fd_pr__nfet_01v8 ad=4.095 pd=8.17 as=7.875 ps=16.25 w=7 l=0.18
.ends

.subckt sky130_ef_io__vssd_lvc_pad DRN_LVC1 DRN_LVC2 BDY2_B2B VSSD_PAD VDDA SRC_BDY_LVC2
+ VCCD SRC_BDY_LVC1 VSWITCH VDDIO AMUXBUS_B AMUXBUS_A VDDIO_Q VSSD VSSIO VCCHIB VSSIO_Q
+ VSSA
Xsky130_fd_io__top_ground_lvc_wpad_1 sky130_fd_io__top_ground_lvc_wpad_1/PADISOR sky130_fd_io__top_ground_lvc_wpad_1/PADISOL
+ VSSIO_Q VCCHIB VDDA VDDIO_Q VSSD_PAD SRC_BDY_LVC1 SRC_BDY_LVC2 BDY2_B2B DRN_LVC2
+ DRN_LVC1 VSSD BDY2_B2B AMUXBUS_B VSSIO VDDIO VSSD VSWITCH VSSA AMUXBUS_A VCCD sky130_fd_io__top_ground_lvc_wpad
.ends

.subckt sky130_fd_io__sio_clamp_pcap_4x5 a_36_36# a_229_118#
X0 a_36_36# a_229_118# a_36_36# a_36_36# sky130_fd_pr__nfet_g5v0d10v5 ad=1.325 pd=10.53 as=0 ps=0 w=5 l=4
.ends

.subckt sky130_fd_io__esd_rcclamp_nfetcap a_179_100# a_n14_18#
X0 a_n14_18# a_179_100# a_n14_18# a_n14_18# sky130_fd_pr__nfet_g5v0d10v5 ad=1.325 pd=10.53 as=0 ps=0 w=5 l=8
.ends

.subckt sky130_fd_io__hvc_clampv2 m2_5179_0# w_1040_5785# sky130_fd_io__com_busses_esd_0/sky130_fd_io__pad_esd_0/m5_1354_20500#
+ m3_10082_12712# m3_103_12712# sky130_fd_io__com_busses_esd_0/sky130_fd_io__com_bus_hookup_0/VDDIO_Q
+ sky130_fd_io__com_busses_esd_0/sky130_fd_io__com_bus_hookup_0/AMUXBUS_B sky130_fd_io__com_busses_esd_0/sky130_fd_io__com_bus_hookup_0/VSSIO_Q
+ w_2676_441# sky130_fd_io__com_busses_esd_0/sky130_fd_io__com_bus_hookup_0/VCCHIB
+ sky130_fd_io__com_busses_esd_0/sky130_fd_io__com_bus_hookup_0/VSSIO sky130_fd_io__com_busses_esd_0/sky130_fd_io__com_bus_hookup_0/VDDA
+ sky130_fd_io__com_busses_esd_0/sky130_fd_io__com_bus_hookup_0/VDDIO m3_99_0# sky130_fd_io__com_busses_esd_0/sky130_fd_io__com_bus_hookup_0/VSSD
+ sky130_fd_io__com_busses_esd_0/sky130_fd_io__com_bus_hookup_0/VSWITCH sky130_fd_io__com_busses_esd_0/sky130_fd_io__com_bus_hookup_0/VSSA
+ sky130_fd_io__com_busses_esd_0/sky130_fd_io__com_bus_hookup_0/AMUXBUS_A sky130_fd_io__com_busses_esd_0/sky130_fd_io__com_bus_hookup_0/VCCD
Xsky130_fd_io__sio_clamp_pcap_4x5_0[0] w_2676_441# a_1268_5934# sky130_fd_io__sio_clamp_pcap_4x5
Xsky130_fd_io__sio_clamp_pcap_4x5_0[1] w_2676_441# a_1268_5934# sky130_fd_io__sio_clamp_pcap_4x5
Xsky130_fd_io__sio_clamp_pcap_4x5_0[2] w_2676_441# a_1268_5934# sky130_fd_io__sio_clamp_pcap_4x5
Xsky130_fd_io__com_busses_esd_0 sky130_fd_io__com_busses_esd_0/sky130_fd_io__com_bus_hookup_0/VCCHIB
+ sky130_fd_io__com_busses_esd_0/sky130_fd_io__pad_esd_0/m5_1354_20500# sky130_fd_io__com_busses_esd_0/sky130_fd_io__com_bus_hookup_0/VSSD
+ m3_99_0# sky130_fd_io__com_busses_esd_0/sky130_fd_io__com_bus_hookup_0/AMUXBUS_A
+ sky130_fd_io__com_busses_esd_0/sky130_fd_io__com_bus_hookup_0/VCCD sky130_fd_io__com_busses_esd_0/sky130_fd_io__com_bus_hookup_0/AMUXBUS_B
+ sky130_fd_io__com_busses_esd_0/sky130_fd_io__com_bus_hookup_0/VDDIO sky130_fd_io__com_busses_esd_0/sky130_fd_io__com_bus_hookup_0/VSSA
+ sky130_fd_io__com_busses_esd_0/sky130_fd_io__com_bus_hookup_0/VSSIO sky130_fd_io__com_busses_esd_0/sky130_fd_io__com_bus_hookup_0/VSWITCH
+ sky130_fd_io__com_busses_esd_0/sky130_fd_io__com_bus_hookup_0/VDDA sky130_fd_io__com_busses_esd_0/sky130_fd_io__com_bus_hookup_0/VSSIO_Q
+ sky130_fd_io__com_busses_esd_0/sky130_fd_io__com_bus_hookup_0/VDDIO_Q sky130_fd_io__com_busses_esd
Xsky130_fd_io__sio_clamp_pcap_4x5_1 w_2676_441# a_1268_5934# sky130_fd_io__sio_clamp_pcap_4x5
Xsky130_fd_io__esd_rcclamp_nfetcap_0[0|0] a_1268_5934# w_2676_441# sky130_fd_io__esd_rcclamp_nfetcap
Xsky130_fd_io__esd_rcclamp_nfetcap_0[1|0] a_1268_5934# w_2676_441# sky130_fd_io__esd_rcclamp_nfetcap
Xsky130_fd_io__esd_rcclamp_nfetcap_0[2|0] a_1268_5934# w_2676_441# sky130_fd_io__esd_rcclamp_nfetcap
Xsky130_fd_io__esd_rcclamp_nfetcap_0[0|1] a_1268_5934# w_2676_441# sky130_fd_io__esd_rcclamp_nfetcap
Xsky130_fd_io__esd_rcclamp_nfetcap_0[1|1] a_1268_5934# w_2676_441# sky130_fd_io__esd_rcclamp_nfetcap
Xsky130_fd_io__esd_rcclamp_nfetcap_0[2|1] a_1268_5934# w_2676_441# sky130_fd_io__esd_rcclamp_nfetcap
Xsky130_fd_io__esd_rcclamp_nfetcap_0[0|2] a_1268_5934# w_2676_441# sky130_fd_io__esd_rcclamp_nfetcap
Xsky130_fd_io__esd_rcclamp_nfetcap_0[1|2] a_1268_5934# w_2676_441# sky130_fd_io__esd_rcclamp_nfetcap
Xsky130_fd_io__esd_rcclamp_nfetcap_0[2|2] a_1268_5934# w_2676_441# sky130_fd_io__esd_rcclamp_nfetcap
Xsky130_fd_io__esd_rcclamp_nfetcap_0[0|3] a_1268_5934# w_2676_441# sky130_fd_io__esd_rcclamp_nfetcap
Xsky130_fd_io__esd_rcclamp_nfetcap_0[1|3] a_1268_5934# w_2676_441# sky130_fd_io__esd_rcclamp_nfetcap
Xsky130_fd_io__esd_rcclamp_nfetcap_0[2|3] a_1268_5934# w_2676_441# sky130_fd_io__esd_rcclamp_nfetcap
Xsky130_fd_io__esd_rcclamp_nfetcap_0[0|4] a_1268_5934# w_2676_441# sky130_fd_io__esd_rcclamp_nfetcap
Xsky130_fd_io__esd_rcclamp_nfetcap_0[1|4] a_1268_5934# w_2676_441# sky130_fd_io__esd_rcclamp_nfetcap
Xsky130_fd_io__esd_rcclamp_nfetcap_0[2|4] a_1268_5934# w_2676_441# sky130_fd_io__esd_rcclamp_nfetcap
X0 w_1040_5785# a_1368_5960# w_2676_441# w_2676_441# sky130_fd_pr__nfet_g5v0d10v5 ad=15.1 pd=21.51 as=13.9 ps=41.39 w=20 l=0.5
X1 w_1040_5785# a_1268_5934# a_1368_5960# w_1040_5785# sky130_fd_pr__pfet_g5v0d10v5 ad=0.98 pd=7.28 as=0.98 ps=7.28 w=7 l=0.5
X2 w_2676_441# a_1368_5960# w_1040_5785# w_2676_441# sky130_fd_pr__nfet_g5v0d10v5 ad=6.95 pd=21.39 as=7.55 ps=11.51 w=10 l=0.5
X3 w_1040_5785# a_1368_5960# w_2676_441# w_2676_441# sky130_fd_pr__nfet_g5v0d10v5 ad=15.1 pd=21.51 as=13.9 ps=41.39 w=20 l=0.5
X4 a_1368_5960# a_1268_5934# w_1040_5785# w_1040_5785# sky130_fd_pr__pfet_g5v0d10v5 ad=0.98 pd=7.28 as=1.855 ps=14.53 w=7 l=0.5
X5 w_1040_5785# a_1368_5960# w_2676_441# w_2676_441# sky130_fd_pr__nfet_g5v0d10v5 ad=15.1 pd=21.51 as=13.9 ps=41.39 w=20 l=0.5
X6 w_1040_5785# a_1368_5960# w_2676_441# w_2676_441# sky130_fd_pr__nfet_g5v0d10v5 ad=15.1 pd=21.51 as=13.9 ps=41.39 w=20 l=0.5
X7 w_1040_5785# a_1368_5960# w_2676_441# w_2676_441# sky130_fd_pr__nfet_g5v0d10v5 ad=15.1 pd=21.51 as=13.9 ps=41.39 w=20 l=0.5
X8 w_2676_441# a_1368_5960# w_1040_5785# w_2676_441# sky130_fd_pr__nfet_g5v0d10v5 ad=13.9 pd=41.39 as=15.1 ps=21.51 w=20 l=0.5
X9 w_2676_441# a_1368_5960# w_1040_5785# w_2676_441# sky130_fd_pr__nfet_g5v0d10v5 ad=13.9 pd=41.39 as=15.1 ps=21.51 w=20 l=0.5
X10 a_1368_5960# a_1268_5934# w_1040_5785# w_1040_5785# sky130_fd_pr__pfet_g5v0d10v5 ad=0.98 pd=7.28 as=0.98 ps=7.28 w=7 l=0.5
X11 w_1040_5785# a_1268_5934# a_1368_5960# w_1040_5785# sky130_fd_pr__pfet_g5v0d10v5 ad=0.98 pd=7.28 as=0.98 ps=7.28 w=7 l=0.5
X12 w_2676_441# a_1368_5960# w_1040_5785# w_2676_441# sky130_fd_pr__nfet_g5v0d10v5 ad=13.9 pd=41.39 as=15.1 ps=21.51 w=20 l=0.5
X13 w_1040_5785# a_1368_5960# w_2676_441# w_2676_441# sky130_fd_pr__nfet_g5v0d10v5 ad=15.1 pd=21.51 as=13.9 ps=41.39 w=20 l=0.5
X14 a_1368_5960# a_1268_5934# w_1040_5785# w_1040_5785# sky130_fd_pr__pfet_g5v0d10v5 ad=0.98 pd=7.28 as=0.98 ps=7.28 w=7 l=0.5
X15 w_1040_5785# a_1268_5934# a_1368_5960# w_1040_5785# sky130_fd_pr__pfet_g5v0d10v5 ad=0.98 pd=7.28 as=0.98 ps=7.28 w=7 l=0.5
X16 w_1040_5785# a_1268_5934# a_1368_5960# w_1040_5785# sky130_fd_pr__pfet_g5v0d10v5 ad=0.98 pd=7.28 as=0.98 ps=7.28 w=7 l=0.5
X17 w_1040_5785# a_1368_5960# w_2676_441# w_2676_441# sky130_fd_pr__nfet_g5v0d10v5 ad=7.55 pd=11.51 as=6.95 ps=21.39 w=10 l=0.5
X18 a_1368_5960# a_1268_5934# w_1040_5785# w_1040_5785# sky130_fd_pr__pfet_g5v0d10v5 ad=0.98 pd=7.28 as=0.98 ps=7.28 w=7 l=0.5
X19 w_1040_5785# a_1268_5934# a_1368_5960# w_1040_5785# sky130_fd_pr__pfet_g5v0d10v5 ad=0.98 pd=7.28 as=0.98 ps=7.28 w=7 l=0.5
X20 w_1040_5785# a_1368_5960# w_2676_441# w_2676_441# sky130_fd_pr__nfet_g5v0d10v5 ad=15.1 pd=21.51 as=13.9 ps=41.39 w=20 l=0.5
X21 w_2676_441# a_1368_5960# w_1040_5785# w_2676_441# sky130_fd_pr__nfet_g5v0d10v5 ad=13.9 pd=41.39 as=15.1 ps=21.51 w=20 l=0.5
X22 w_1040_5785# a_1368_5960# w_2676_441# w_2676_441# sky130_fd_pr__nfet_g5v0d10v5 ad=7.55 pd=11.51 as=6.95 ps=21.39 w=10 l=0.5
X23 w_2676_441# a_1368_5960# w_1040_5785# w_2676_441# sky130_fd_pr__nfet_g5v0d10v5 ad=13.9 pd=41.39 as=15.1 ps=21.51 w=20 l=0.5
X24 w_1040_5785# a_1368_5960# w_2676_441# w_2676_441# sky130_fd_pr__nfet_g5v0d10v5 ad=15.1 pd=21.51 as=13.9 ps=41.39 w=20 l=0.5
X25 w_2676_441# a_1368_5960# w_1040_5785# w_2676_441# sky130_fd_pr__nfet_g5v0d10v5 ad=6.95 pd=21.39 as=7.55 ps=11.51 w=10 l=0.5
X26 w_1040_5785# a_1368_5960# w_2676_441# w_2676_441# sky130_fd_pr__nfet_g5v0d10v5 ad=15.1 pd=21.51 as=13.9 ps=41.39 w=20 l=0.5
X27 w_1040_5785# a_1368_5960# w_2676_441# w_2676_441# sky130_fd_pr__nfet_g5v0d10v5 ad=15.1 pd=21.51 as=13.9 ps=41.39 w=20 l=0.5
X28 a_1368_5960# a_1268_5934# w_1040_5785# w_1040_5785# sky130_fd_pr__pfet_g5v0d10v5 ad=0.98 pd=7.28 as=0.98 ps=7.28 w=7 l=0.5
X29 w_1040_5785# a_1368_5960# w_2676_441# w_2676_441# sky130_fd_pr__nfet_g5v0d10v5 ad=7.55 pd=11.51 as=6.95 ps=21.39 w=10 l=0.5
X30 a_1368_5960# a_1268_5934# w_2676_441# w_2676_441# sky130_fd_pr__nfet_g5v0d10v5 ad=0.98 pd=7.28 as=0.98 ps=7.28 w=7 l=0.5
X31 w_1040_5785# a_1268_5934# a_1368_5960# w_1040_5785# sky130_fd_pr__pfet_g5v0d10v5 ad=0.98 pd=7.28 as=0.98 ps=7.28 w=7 l=0.5
X32 w_2676_441# a_1368_5960# w_1040_5785# w_2676_441# sky130_fd_pr__nfet_g5v0d10v5 ad=6.95 pd=21.39 as=7.55 ps=11.51 w=10 l=0.5
X33 w_2676_441# a_1368_5960# w_1040_5785# w_2676_441# sky130_fd_pr__nfet_g5v0d10v5 ad=13.9 pd=41.39 as=15.1 ps=21.51 w=20 l=0.5
X34 a_1368_5960# a_1268_5934# w_1040_5785# w_1040_5785# sky130_fd_pr__pfet_g5v0d10v5 ad=0.98 pd=7.28 as=0.98 ps=7.28 w=7 l=0.5
X35 w_1040_5785# a_1268_5934# a_1368_5960# w_1040_5785# sky130_fd_pr__pfet_g5v0d10v5 ad=0.98 pd=7.28 as=0.98 ps=7.28 w=7 l=0.5
X36 w_2676_441# a_1368_5960# w_1040_5785# w_2676_441# sky130_fd_pr__nfet_g5v0d10v5 ad=13.9 pd=41.39 as=15.1 ps=21.51 w=20 l=0.5
X37 a_1368_5960# a_1268_5934# w_1040_5785# w_1040_5785# sky130_fd_pr__pfet_g5v0d10v5 ad=0.98 pd=7.28 as=0.98 ps=7.28 w=7 l=0.5
X38 w_1040_5785# a_1368_5960# w_2676_441# w_2676_441# sky130_fd_pr__nfet_g5v0d10v5 ad=15.1 pd=21.51 as=13.9 ps=41.39 w=20 l=0.5
X39 w_2676_441# a_1368_5960# w_1040_5785# w_2676_441# sky130_fd_pr__nfet_g5v0d10v5 ad=13.9 pd=41.39 as=15.1 ps=21.51 w=20 l=0.5
X40 w_2676_441# a_1368_5960# w_1040_5785# w_2676_441# sky130_fd_pr__nfet_g5v0d10v5 ad=13.9 pd=41.39 as=15.1 ps=21.51 w=20 l=0.5
X41 a_1368_5960# a_1268_5934# w_2676_441# w_2676_441# sky130_fd_pr__nfet_g5v0d10v5 ad=0.98 pd=7.28 as=0.98 ps=7.28 w=7 l=0.5
X42 a_1368_5960# a_1268_5934# w_1040_5785# w_1040_5785# sky130_fd_pr__pfet_g5v0d10v5 ad=0.98 pd=7.28 as=0.98 ps=7.28 w=7 l=0.5
X43 w_1040_5785# a_1268_5934# a_1368_5960# w_1040_5785# sky130_fd_pr__pfet_g5v0d10v5 ad=0.98 pd=7.28 as=0.98 ps=7.28 w=7 l=0.5
X44 w_1040_5785# a_1368_5960# w_2676_441# w_2676_441# sky130_fd_pr__nfet_g5v0d10v5 ad=15.1 pd=21.51 as=13.9 ps=41.39 w=20 l=0.5
X45 w_2676_441# a_1368_5960# w_1040_5785# w_2676_441# sky130_fd_pr__nfet_g5v0d10v5 ad=13.9 pd=41.39 as=15.1 ps=21.51 w=20 l=0.5
X46 w_1040_5785# a_1368_5960# w_2676_441# w_2676_441# sky130_fd_pr__nfet_g5v0d10v5 ad=15.1 pd=21.51 as=13.9 ps=41.39 w=20 l=0.5
X47 w_2676_441# a_1268_5934# a_1368_5960# w_2676_441# sky130_fd_pr__nfet_g5v0d10v5 ad=0.98 pd=7.28 as=0.98 ps=7.28 w=7 l=0.5
X48 w_1040_5785# a_1268_5934# a_1368_5960# w_1040_5785# sky130_fd_pr__pfet_g5v0d10v5 ad=0.98 pd=7.28 as=0.98 ps=7.28 w=7 l=0.5
X49 w_1040_5785# a_1368_5960# w_2676_441# w_2676_441# sky130_fd_pr__nfet_g5v0d10v5 ad=7.55 pd=11.51 as=6.95 ps=21.39 w=10 l=0.5
X50 w_1040_5785# a_1368_5960# w_2676_441# w_2676_441# sky130_fd_pr__nfet_g5v0d10v5 ad=15.1 pd=21.51 as=13.9 ps=41.39 w=20 l=0.5
X51 w_1040_5785# a_1368_5960# w_2676_441# w_2676_441# sky130_fd_pr__nfet_g5v0d10v5 ad=15.1 pd=21.51 as=13.9 ps=41.39 w=20 l=0.5
X52 a_1368_5960# a_1268_5934# w_2676_441# w_2676_441# sky130_fd_pr__nfet_g5v0d10v5 ad=0.98 pd=7.28 as=0.98 ps=7.28 w=7 l=0.5
X53 a_1368_5960# a_1268_5934# w_1040_5785# w_1040_5785# sky130_fd_pr__pfet_g5v0d10v5 ad=0.98 pd=7.28 as=0.98 ps=7.28 w=7 l=0.5
X54 w_1040_5785# a_1368_5960# w_2676_441# w_2676_441# sky130_fd_pr__nfet_g5v0d10v5 ad=15.1 pd=21.51 as=13.9 ps=41.39 w=20 l=0.5
X55 w_2676_441# a_1268_5934# a_1368_5960# w_2676_441# sky130_fd_pr__nfet_g5v0d10v5 ad=0.98 pd=7.28 as=0.98 ps=7.28 w=7 l=0.5
X56 w_2676_441# a_1368_5960# w_1040_5785# w_2676_441# sky130_fd_pr__nfet_g5v0d10v5 ad=13.9 pd=41.39 as=15.1 ps=21.51 w=20 l=0.5
X57 w_2676_441# a_1368_5960# w_1040_5785# w_2676_441# sky130_fd_pr__nfet_g5v0d10v5 ad=13.9 pd=41.39 as=15.1 ps=21.51 w=20 l=0.5
X58 w_2676_441# a_1368_5960# w_1040_5785# w_2676_441# sky130_fd_pr__nfet_g5v0d10v5 ad=13.9 pd=41.39 as=15.1 ps=21.51 w=20 l=0.5
X59 w_1040_5785# a_1368_5960# w_2676_441# w_2676_441# sky130_fd_pr__nfet_g5v0d10v5 ad=15.1 pd=21.51 as=13.9 ps=41.39 w=20 l=0.5
X60 w_2676_441# a_1368_5960# w_1040_5785# w_2676_441# sky130_fd_pr__nfet_g5v0d10v5 ad=13.9 pd=41.39 as=15.1 ps=21.51 w=20 l=0.5
X61 w_1040_5785# a_1368_5960# w_2676_441# w_2676_441# sky130_fd_pr__nfet_g5v0d10v5 ad=15.1 pd=21.51 as=13.9 ps=41.39 w=20 l=0.5
X62 w_2676_441# a_1368_5960# w_1040_5785# w_2676_441# sky130_fd_pr__nfet_g5v0d10v5 ad=6.95 pd=21.39 as=7.55 ps=11.51 w=10 l=0.5
X63 w_1040_5785# a_1368_5960# w_2676_441# w_2676_441# sky130_fd_pr__nfet_g5v0d10v5 ad=15.1 pd=21.51 as=13.9 ps=41.39 w=20 l=0.5
X64 w_2676_441# a_1268_5934# w_2676_441# w_2676_441# sky130_fd_pr__nfet_g5v0d10v5 ad=1.325 pd=10.53 as=0 ps=0 w=5 l=4
X65 w_1040_5785# a_1368_5960# w_2676_441# w_2676_441# sky130_fd_pr__nfet_g5v0d10v5 ad=7.55 pd=11.51 as=6.95 ps=21.39 w=10 l=0.5
X66 w_1040_5785# a_1368_5960# w_2676_441# w_2676_441# sky130_fd_pr__nfet_g5v0d10v5 ad=15.1 pd=21.51 as=13.9 ps=41.39 w=20 l=0.5
X67 w_1040_5785# a_1368_5960# w_2676_441# w_2676_441# sky130_fd_pr__nfet_g5v0d10v5 ad=15.1 pd=21.51 as=13.9 ps=41.39 w=20 l=0.5
X68 a_1368_5960# a_1268_5934# w_1040_5785# w_1040_5785# sky130_fd_pr__pfet_g5v0d10v5 ad=0.98 pd=7.28 as=0.98 ps=7.28 w=7 l=0.5
X69 w_2676_441# a_1368_5960# w_1040_5785# w_2676_441# sky130_fd_pr__nfet_g5v0d10v5 ad=13.9 pd=41.39 as=15.1 ps=21.51 w=20 l=0.5
X70 w_2676_441# a_1368_5960# w_1040_5785# w_2676_441# sky130_fd_pr__nfet_g5v0d10v5 ad=13.9 pd=41.39 as=15.1 ps=21.51 w=20 l=0.5
X71 w_2676_441# a_1368_5960# w_1040_5785# w_2676_441# sky130_fd_pr__nfet_g5v0d10v5 ad=13.9 pd=41.39 as=15.1 ps=21.51 w=20 l=0.5
X72 w_2676_441# a_1368_5960# w_1040_5785# w_2676_441# sky130_fd_pr__nfet_g5v0d10v5 ad=6.95 pd=21.39 as=7.55 ps=11.51 w=10 l=0.5
X73 w_2676_441# a_1368_5960# w_1040_5785# w_2676_441# sky130_fd_pr__nfet_g5v0d10v5 ad=13.9 pd=41.39 as=15.1 ps=21.51 w=20 l=0.5
X74 w_2676_441# a_1368_5960# w_1040_5785# w_2676_441# sky130_fd_pr__nfet_g5v0d10v5 ad=13.9 pd=41.39 as=15.1 ps=21.51 w=20 l=0.5
X75 w_2676_441# a_1368_5960# w_1040_5785# w_2676_441# sky130_fd_pr__nfet_g5v0d10v5 ad=13.9 pd=41.39 as=15.1 ps=21.51 w=20 l=0.5
X76 w_2676_441# a_1368_5960# w_1040_5785# w_2676_441# sky130_fd_pr__nfet_g5v0d10v5 ad=13.9 pd=41.39 as=15.1 ps=21.51 w=20 l=0.5
X77 w_1040_5785# a_1368_5960# w_2676_441# w_2676_441# sky130_fd_pr__nfet_g5v0d10v5 ad=15.1 pd=21.51 as=13.9 ps=41.39 w=20 l=0.5
X78 w_2676_441# a_1368_5960# w_1040_5785# w_2676_441# sky130_fd_pr__nfet_g5v0d10v5 ad=13.9 pd=41.39 as=15.1 ps=21.51 w=20 l=0.5
X79 a_1368_5960# a_1268_5934# w_1040_5785# w_1040_5785# sky130_fd_pr__pfet_g5v0d10v5 ad=0.98 pd=7.28 as=0.98 ps=7.28 w=7 l=0.5
X80 w_1040_5785# a_1268_5934# a_1368_5960# w_1040_5785# sky130_fd_pr__pfet_g5v0d10v5 ad=0.98 pd=7.28 as=0.98 ps=7.28 w=7 l=0.5
X81 w_2676_441# a_1368_5960# w_1040_5785# w_2676_441# sky130_fd_pr__nfet_g5v0d10v5 ad=13.9 pd=41.39 as=15.1 ps=21.51 w=20 l=0.5
X82 w_2676_441# a_1368_5960# w_1040_5785# w_2676_441# sky130_fd_pr__nfet_g5v0d10v5 ad=13.9 pd=41.39 as=15.1 ps=21.51 w=20 l=0.5
X83 w_1040_5785# a_1368_5960# w_2676_441# w_2676_441# sky130_fd_pr__nfet_g5v0d10v5 ad=15.1 pd=21.51 as=13.9 ps=41.39 w=20 l=0.5
X84 w_2676_441# a_1368_5960# w_1040_5785# w_2676_441# sky130_fd_pr__nfet_g5v0d10v5 ad=13.9 pd=41.39 as=15.1 ps=21.51 w=20 l=0.5
X85 w_1040_5785# a_1368_5960# w_2676_441# w_2676_441# sky130_fd_pr__nfet_g5v0d10v5 ad=15.1 pd=21.51 as=13.9 ps=41.39 w=20 l=0.5
X86 w_1040_5785# a_1368_5960# w_2676_441# w_2676_441# sky130_fd_pr__nfet_g5v0d10v5 ad=15.1 pd=21.51 as=13.9 ps=41.39 w=20 l=0.5
X87 w_2676_441# a_1368_5960# w_1040_5785# w_2676_441# sky130_fd_pr__nfet_g5v0d10v5 ad=6.95 pd=21.39 as=7.55 ps=11.51 w=10 l=0.5
X88 w_1040_5785# a_1368_5960# w_2676_441# w_2676_441# sky130_fd_pr__nfet_g5v0d10v5 ad=15.1 pd=21.51 as=13.9 ps=41.39 w=20 l=0.5
X89 a_1268_5934# a_1672_8570# sky130_fd_pr__res_generic_po w=0.33 l=470
X90 w_1040_5785# a_1368_5960# w_2676_441# w_2676_441# sky130_fd_pr__nfet_g5v0d10v5 ad=15.1 pd=21.51 as=13.9 ps=41.39 w=20 l=0.5
X91 w_2676_441# a_1368_5960# w_1040_5785# w_2676_441# sky130_fd_pr__nfet_g5v0d10v5 ad=13.9 pd=41.39 as=15.1 ps=21.51 w=20 l=0.5
X92 w_1040_5785# a_1368_5960# w_2676_441# w_2676_441# sky130_fd_pr__nfet_g5v0d10v5 ad=15.1 pd=21.51 as=13.9 ps=41.39 w=20 l=0.5
X93 w_2676_441# a_1268_5934# a_1368_5960# w_2676_441# sky130_fd_pr__nfet_g5v0d10v5 ad=0.98 pd=7.28 as=0.98 ps=7.28 w=7 l=0.5
X94 a_1368_5960# a_1268_5934# w_1040_5785# w_1040_5785# sky130_fd_pr__pfet_g5v0d10v5 ad=0.98 pd=7.28 as=0.98 ps=7.28 w=7 l=0.5
X95 w_1040_5785# a_1368_5960# w_2676_441# w_2676_441# sky130_fd_pr__nfet_g5v0d10v5 ad=15.1 pd=21.51 as=13.9 ps=41.39 w=20 l=0.5
X96 w_1040_5785# a_1268_5934# a_1368_5960# w_1040_5785# sky130_fd_pr__pfet_g5v0d10v5 ad=0.98 pd=7.28 as=0.98 ps=7.28 w=7 l=0.5
X97 w_1040_5785# a_1368_5960# w_2676_441# w_2676_441# sky130_fd_pr__nfet_g5v0d10v5 ad=15.1 pd=21.51 as=13.9 ps=41.39 w=20 l=0.5
X98 w_1040_5785# a_1368_5960# w_2676_441# w_2676_441# sky130_fd_pr__nfet_g5v0d10v5 ad=15.1 pd=21.51 as=13.9 ps=41.39 w=20 l=0.5
X99 w_1040_5785# a_1368_5960# w_2676_441# w_2676_441# sky130_fd_pr__nfet_g5v0d10v5 ad=15.1 pd=21.51 as=13.9 ps=41.39 w=20 l=0.5
X100 w_1040_5785# a_1368_5960# w_2676_441# w_2676_441# sky130_fd_pr__nfet_g5v0d10v5 ad=7.55 pd=11.51 as=6.95 ps=21.39 w=10 l=0.5
X101 w_2676_441# a_1368_5960# w_1040_5785# w_2676_441# sky130_fd_pr__nfet_g5v0d10v5 ad=13.9 pd=41.39 as=15.1 ps=21.51 w=20 l=0.5
X102 w_2676_441# a_1368_5960# w_1040_5785# w_2676_441# sky130_fd_pr__nfet_g5v0d10v5 ad=13.9 pd=41.39 as=15.1 ps=21.51 w=20 l=0.5
X103 a_1368_5960# a_1268_5934# w_1040_5785# w_1040_5785# sky130_fd_pr__pfet_g5v0d10v5 ad=0.98 pd=7.28 as=0.98 ps=7.28 w=7 l=0.5
X104 w_2676_441# a_1368_5960# w_1040_5785# w_2676_441# sky130_fd_pr__nfet_g5v0d10v5 ad=13.9 pd=41.39 as=15.1 ps=21.51 w=20 l=0.5
X105 w_1040_5785# a_1368_5960# w_2676_441# w_2676_441# sky130_fd_pr__nfet_g5v0d10v5 ad=15.1 pd=21.51 as=13.9 ps=41.39 w=20 l=0.5
X106 w_2676_441# a_1268_5934# a_1368_5960# w_2676_441# sky130_fd_pr__nfet_g5v0d10v5 ad=0.98 pd=7.28 as=0.98 ps=7.28 w=7 l=0.5
X107 w_1040_5785# a_1268_5934# a_1368_5960# w_1040_5785# sky130_fd_pr__pfet_g5v0d10v5 ad=0.98 pd=7.28 as=0.98 ps=7.28 w=7 l=0.5
X108 w_1040_5785# a_1368_5960# w_2676_441# w_2676_441# sky130_fd_pr__nfet_g5v0d10v5 ad=15.1 pd=21.51 as=13.9 ps=41.39 w=20 l=0.5
X109 w_2676_441# a_1368_5960# w_1040_5785# w_2676_441# sky130_fd_pr__nfet_g5v0d10v5 ad=13.9 pd=41.39 as=15.1 ps=21.51 w=20 l=0.5
X110 a_1368_5960# a_1268_5934# w_2676_441# w_2676_441# sky130_fd_pr__nfet_g5v0d10v5 ad=0.98 pd=7.28 as=0.98 ps=7.28 w=7 l=0.5
X111 a_1368_5960# a_1268_5934# w_1040_5785# w_1040_5785# sky130_fd_pr__pfet_g5v0d10v5 ad=0.98 pd=7.28 as=0.98 ps=7.28 w=7 l=0.5
X112 w_1040_5785# a_1368_5960# w_2676_441# w_2676_441# sky130_fd_pr__nfet_g5v0d10v5 ad=7.55 pd=11.51 as=6.95 ps=21.39 w=10 l=0.5
X113 w_2676_441# a_1368_5960# w_1040_5785# w_2676_441# sky130_fd_pr__nfet_g5v0d10v5 ad=13.9 pd=41.39 as=15.1 ps=21.51 w=20 l=0.5
X114 a_1368_5960# a_1268_5934# w_1040_5785# w_1040_5785# sky130_fd_pr__pfet_g5v0d10v5 ad=0.98 pd=7.28 as=0.98 ps=7.28 w=7 l=0.5
X115 w_2676_441# a_1368_5960# w_1040_5785# w_2676_441# sky130_fd_pr__nfet_g5v0d10v5 ad=13.9 pd=41.39 as=15.1 ps=21.51 w=20 l=0.5
X116 w_2676_441# a_1268_5934# a_1368_5960# w_2676_441# sky130_fd_pr__nfet_g5v0d10v5 ad=0.98 pd=7.28 as=0.98 ps=7.28 w=7 l=0.5
X117 w_1040_5785# a_1268_5934# a_1368_5960# w_1040_5785# sky130_fd_pr__pfet_g5v0d10v5 ad=0.98 pd=7.28 as=0.98 ps=7.28 w=7 l=0.5
X118 w_1040_5785# a_1368_5960# w_2676_441# w_2676_441# sky130_fd_pr__nfet_g5v0d10v5 ad=15.1 pd=21.51 as=13.9 ps=41.39 w=20 l=0.5
X119 a_1368_5960# a_1268_5934# w_1040_5785# w_1040_5785# sky130_fd_pr__pfet_g5v0d10v5 ad=0.98 pd=7.28 as=0.98 ps=7.28 w=7 l=0.5
X120 w_1040_5785# a_1368_5960# w_2676_441# w_2676_441# sky130_fd_pr__nfet_g5v0d10v5 ad=15.1 pd=21.51 as=13.9 ps=41.39 w=20 l=0.5
X121 w_1040_5785# a_1368_5960# w_2676_441# w_2676_441# sky130_fd_pr__nfet_g5v0d10v5 ad=15.1 pd=21.51 as=13.9 ps=41.39 w=20 l=0.5
X122 w_2676_441# a_1368_5960# w_1040_5785# w_2676_441# sky130_fd_pr__nfet_g5v0d10v5 ad=6.95 pd=21.39 as=7.55 ps=11.51 w=10 l=0.5
X123 w_2676_441# a_1368_5960# w_1040_5785# w_2676_441# sky130_fd_pr__nfet_g5v0d10v5 ad=6.95 pd=21.39 as=7.55 ps=11.51 w=10 l=0.5
X124 w_2676_441# a_1368_5960# w_1040_5785# w_2676_441# sky130_fd_pr__nfet_g5v0d10v5 ad=13.9 pd=41.39 as=15.1 ps=21.51 w=20 l=0.5
X125 w_1040_5785# a_1268_5934# a_1368_5960# w_1040_5785# sky130_fd_pr__pfet_g5v0d10v5 ad=0.98 pd=7.28 as=0.98 ps=7.28 w=7 l=0.5
X126 w_1040_5785# a_1368_5960# w_2676_441# w_2676_441# sky130_fd_pr__nfet_g5v0d10v5 ad=15.1 pd=21.51 as=13.9 ps=41.39 w=20 l=0.5
X127 w_1040_5785# a_1368_5960# w_2676_441# w_2676_441# sky130_fd_pr__nfet_g5v0d10v5 ad=15.1 pd=21.51 as=13.9 ps=41.39 w=20 l=0.5
X128 w_2676_441# a_1368_5960# w_1040_5785# w_2676_441# sky130_fd_pr__nfet_g5v0d10v5 ad=13.9 pd=41.39 as=15.1 ps=21.51 w=20 l=0.5
X129 a_1368_5960# a_1268_5934# w_1040_5785# w_1040_5785# sky130_fd_pr__pfet_g5v0d10v5 ad=0.98 pd=7.28 as=0.98 ps=7.28 w=7 l=0.5
X130 w_1040_5785# a_1368_5960# w_2676_441# w_2676_441# sky130_fd_pr__nfet_g5v0d10v5 ad=15.1 pd=21.51 as=13.9 ps=41.39 w=20 l=0.5
X131 w_1040_5785# a_1268_5934# a_1368_5960# w_1040_5785# sky130_fd_pr__pfet_g5v0d10v5 ad=0.98 pd=7.28 as=0.98 ps=7.28 w=7 l=0.5
X132 w_1040_5785# a_1268_5934# a_1368_5960# w_1040_5785# sky130_fd_pr__pfet_g5v0d10v5 ad=0.98 pd=7.28 as=0.98 ps=7.28 w=7 l=0.5
X133 a_1368_5960# a_1268_5934# w_1040_5785# w_1040_5785# sky130_fd_pr__pfet_g5v0d10v5 ad=0.98 pd=7.28 as=0.98 ps=7.28 w=7 l=0.5
X134 w_1040_5785# a_1268_5934# a_1368_5960# w_1040_5785# sky130_fd_pr__pfet_g5v0d10v5 ad=0.98 pd=7.28 as=0.98 ps=7.28 w=7 l=0.5
X135 a_1368_5960# a_1268_5934# w_1040_5785# w_1040_5785# sky130_fd_pr__pfet_g5v0d10v5 ad=0.98 pd=7.28 as=0.98 ps=7.28 w=7 l=0.5
X136 w_2676_441# a_1368_5960# w_1040_5785# w_2676_441# sky130_fd_pr__nfet_g5v0d10v5 ad=13.9 pd=41.39 as=15.1 ps=21.51 w=20 l=0.5
R0 m3_99_0# m3_103_12712# sky130_fd_pr__res_generic_m3 w=12.125 l=10m
X137 w_1040_5785# a_1268_5934# a_1368_5960# w_1040_5785# sky130_fd_pr__pfet_g5v0d10v5 ad=0.98 pd=7.28 as=0.98 ps=7.28 w=7 l=0.5
X138 w_2676_441# a_1368_5960# w_1040_5785# w_2676_441# sky130_fd_pr__nfet_g5v0d10v5 ad=13.9 pd=41.39 as=15.1 ps=21.51 w=20 l=0.5
X139 w_1040_5785# a_1268_5934# a_1368_5960# w_1040_5785# sky130_fd_pr__pfet_g5v0d10v5 ad=0.98 pd=7.28 as=0.98 ps=7.28 w=7 l=0.5
X140 w_1040_5785# a_1368_5960# w_2676_441# w_2676_441# sky130_fd_pr__nfet_g5v0d10v5 ad=15.1 pd=21.51 as=13.9 ps=41.39 w=20 l=0.5
X141 a_1368_5960# a_1268_5934# w_1040_5785# w_1040_5785# sky130_fd_pr__pfet_g5v0d10v5 ad=0.98 pd=7.28 as=0.98 ps=7.28 w=7 l=0.5
X142 w_1040_5785# a_1368_5960# w_2676_441# w_2676_441# sky130_fd_pr__nfet_g5v0d10v5 ad=7.55 pd=11.51 as=6.95 ps=21.39 w=10 l=0.5
X143 w_1040_5785# a_214_8570# sky130_fd_pr__res_generic_po w=0.33 l=700
X144 w_2676_441# a_1368_5960# w_1040_5785# w_2676_441# sky130_fd_pr__nfet_g5v0d10v5 ad=13.9 pd=41.39 as=15.1 ps=21.51 w=20 l=0.5
X145 w_1040_5785# a_1368_5960# w_2676_441# w_2676_441# sky130_fd_pr__nfet_g5v0d10v5 ad=15.1 pd=21.51 as=13.9 ps=41.39 w=20 l=0.5
X146 w_1040_5785# a_1268_5934# a_1368_5960# w_1040_5785# sky130_fd_pr__pfet_g5v0d10v5 ad=1.855 pd=14.53 as=0.98 ps=7.28 w=7 l=0.5
X147 w_1040_5785# a_1368_5960# w_2676_441# w_2676_441# sky130_fd_pr__nfet_g5v0d10v5 ad=15.1 pd=21.51 as=13.9 ps=41.39 w=20 l=0.5
X148 a_1368_5960# a_1268_5934# w_2676_441# w_2676_441# sky130_fd_pr__nfet_g5v0d10v5 ad=0.98 pd=7.28 as=0.98 ps=7.28 w=7 l=0.5
X149 w_2676_441# a_1268_5934# a_1368_5960# w_2676_441# sky130_fd_pr__nfet_g5v0d10v5 ad=0.98 pd=7.28 as=0.98 ps=7.28 w=7 l=0.5
X150 a_1368_5960# a_1268_5934# w_1040_5785# w_1040_5785# sky130_fd_pr__pfet_g5v0d10v5 ad=0.98 pd=7.28 as=0.98 ps=7.28 w=7 l=0.5
X151 w_1040_5785# a_1268_5934# a_1368_5960# w_1040_5785# sky130_fd_pr__pfet_g5v0d10v5 ad=0.98 pd=7.28 as=0.98 ps=7.28 w=7 l=0.5
X152 a_1368_5960# a_1268_5934# w_2676_441# w_2676_441# sky130_fd_pr__nfet_g5v0d10v5 ad=0.98 pd=7.28 as=1.855 ps=14.53 w=7 l=0.5
X153 a_1368_5960# a_1268_5934# w_1040_5785# w_1040_5785# sky130_fd_pr__pfet_g5v0d10v5 ad=0.98 pd=7.28 as=0.98 ps=7.28 w=7 l=0.5
X154 w_2676_441# a_1368_5960# w_1040_5785# w_2676_441# sky130_fd_pr__nfet_g5v0d10v5 ad=13.9 pd=41.39 as=15.1 ps=21.51 w=20 l=0.5
X155 a_1368_5960# a_1268_5934# w_2676_441# w_2676_441# sky130_fd_pr__nfet_g5v0d10v5 ad=0.98 pd=7.28 as=0.98 ps=7.28 w=7 l=0.5
X156 a_1368_5960# a_1268_5934# w_1040_5785# w_1040_5785# sky130_fd_pr__pfet_g5v0d10v5 ad=0.98 pd=7.28 as=0.98 ps=7.28 w=7 l=0.5
X157 w_2676_441# a_1368_5960# w_1040_5785# w_2676_441# sky130_fd_pr__nfet_g5v0d10v5 ad=13.9 pd=41.39 as=15.1 ps=21.51 w=20 l=0.5
X158 w_1040_5785# a_1268_5934# a_1368_5960# w_1040_5785# sky130_fd_pr__pfet_g5v0d10v5 ad=0.98 pd=7.28 as=0.98 ps=7.28 w=7 l=0.5
X159 w_2676_441# a_1368_5960# w_1040_5785# w_2676_441# sky130_fd_pr__nfet_g5v0d10v5 ad=13.9 pd=41.39 as=15.1 ps=21.51 w=20 l=0.5
X160 w_1040_5785# a_1368_5960# w_2676_441# w_2676_441# sky130_fd_pr__nfet_g5v0d10v5 ad=15.1 pd=21.51 as=13.9 ps=41.39 w=20 l=0.5
X161 w_2676_441# a_1368_5960# w_1040_5785# w_2676_441# sky130_fd_pr__nfet_g5v0d10v5 ad=13.9 pd=41.39 as=15.1 ps=21.51 w=20 l=0.5
X162 w_1040_5785# a_1368_5960# w_2676_441# w_2676_441# sky130_fd_pr__nfet_g5v0d10v5 ad=15.1 pd=21.51 as=13.9 ps=41.39 w=20 l=0.5
X163 w_2676_441# a_1368_5960# w_1040_5785# w_2676_441# sky130_fd_pr__nfet_g5v0d10v5 ad=13.9 pd=41.39 as=15.1 ps=21.51 w=20 l=0.5
X164 w_2676_441# a_1368_5960# w_1040_5785# w_2676_441# sky130_fd_pr__nfet_g5v0d10v5 ad=13.9 pd=41.39 as=15.1 ps=21.51 w=20 l=0.5
X165 w_1040_5785# a_1268_5934# a_1368_5960# w_1040_5785# sky130_fd_pr__pfet_g5v0d10v5 ad=0.98 pd=7.28 as=0.98 ps=7.28 w=7 l=0.5
X166 w_2676_441# a_1368_5960# w_1040_5785# w_2676_441# sky130_fd_pr__nfet_g5v0d10v5 ad=13.9 pd=41.39 as=15.1 ps=21.51 w=20 l=0.5
X167 w_2676_441# a_1368_5960# w_1040_5785# w_2676_441# sky130_fd_pr__nfet_g5v0d10v5 ad=13.9 pd=41.39 as=15.1 ps=21.51 w=20 l=0.5
X168 a_1672_8570# a_214_8570# sky130_fd_pr__res_generic_po w=0.33 l=1.55k
X169 w_1040_5785# a_1368_5960# w_2676_441# w_2676_441# sky130_fd_pr__nfet_g5v0d10v5 ad=7.55 pd=11.51 as=6.95 ps=21.39 w=10 l=0.5
X170 w_1040_5785# a_1368_5960# w_2676_441# w_2676_441# sky130_fd_pr__nfet_g5v0d10v5 ad=15.1 pd=21.51 as=13.9 ps=41.39 w=20 l=0.5
X171 w_2676_441# a_1368_5960# w_1040_5785# w_2676_441# sky130_fd_pr__nfet_g5v0d10v5 ad=13.9 pd=41.39 as=15.1 ps=21.51 w=20 l=0.5
X172 w_1040_5785# a_1368_5960# w_2676_441# w_2676_441# sky130_fd_pr__nfet_g5v0d10v5 ad=15.1 pd=21.51 as=13.9 ps=41.39 w=20 l=0.5
X173 w_2676_441# a_1368_5960# w_1040_5785# w_2676_441# sky130_fd_pr__nfet_g5v0d10v5 ad=13.9 pd=41.39 as=15.1 ps=21.51 w=20 l=0.5
X174 w_2676_441# a_1368_5960# w_1040_5785# w_2676_441# sky130_fd_pr__nfet_g5v0d10v5 ad=6.95 pd=21.39 as=7.55 ps=11.51 w=10 l=0.5
X175 w_1040_5785# a_1368_5960# w_2676_441# w_2676_441# sky130_fd_pr__nfet_g5v0d10v5 ad=15.1 pd=21.51 as=13.9 ps=41.39 w=20 l=0.5
R1 m3_99_0# m3_10082_12712# sky130_fd_pr__res_generic_m3 w=12.125 l=10m
X176 w_1040_5785# a_1368_5960# w_2676_441# w_2676_441# sky130_fd_pr__nfet_g5v0d10v5 ad=15.1 pd=21.51 as=13.9 ps=41.39 w=20 l=0.5
X177 w_1040_5785# a_1368_5960# w_2676_441# w_2676_441# sky130_fd_pr__nfet_g5v0d10v5 ad=15.1 pd=21.51 as=13.9 ps=41.39 w=20 l=0.5
X178 w_2676_441# a_1368_5960# w_1040_5785# w_2676_441# sky130_fd_pr__nfet_g5v0d10v5 ad=13.9 pd=41.39 as=15.1 ps=21.51 w=20 l=0.5
X179 w_1040_5785# a_1368_5960# w_2676_441# w_2676_441# sky130_fd_pr__nfet_g5v0d10v5 ad=15.1 pd=21.51 as=13.9 ps=41.39 w=20 l=0.5
X180 w_1040_5785# a_1368_5960# w_2676_441# w_2676_441# sky130_fd_pr__nfet_g5v0d10v5 ad=15.1 pd=21.51 as=13.9 ps=41.39 w=20 l=0.5
X181 w_1040_5785# a_1368_5960# w_2676_441# w_2676_441# sky130_fd_pr__nfet_g5v0d10v5 ad=15.1 pd=21.51 as=13.9 ps=41.39 w=20 l=0.5
X182 w_2676_441# a_1368_5960# w_1040_5785# w_2676_441# sky130_fd_pr__nfet_g5v0d10v5 ad=13.9 pd=41.39 as=15.1 ps=21.51 w=20 l=0.5
X183 w_1040_5785# a_1368_5960# w_2676_441# w_2676_441# sky130_fd_pr__nfet_g5v0d10v5 ad=7.55 pd=11.51 as=6.95 ps=21.39 w=10 l=0.5
X184 w_1040_5785# a_1368_5960# w_2676_441# w_2676_441# sky130_fd_pr__nfet_g5v0d10v5 ad=15.1 pd=21.51 as=13.9 ps=41.39 w=20 l=0.5
X185 w_1040_5785# a_1368_5960# w_2676_441# w_2676_441# sky130_fd_pr__nfet_g5v0d10v5 ad=15.1 pd=21.51 as=13.9 ps=41.39 w=20 l=0.5
X186 w_1040_5785# a_1268_5934# a_1368_5960# w_1040_5785# sky130_fd_pr__pfet_g5v0d10v5 ad=0.98 pd=7.28 as=0.98 ps=7.28 w=7 l=0.5
X187 w_1040_5785# a_1368_5960# w_2676_441# w_2676_441# sky130_fd_pr__nfet_g5v0d10v5 ad=15.1 pd=21.51 as=13.9 ps=41.39 w=20 l=0.5
X188 a_1368_5960# a_1268_5934# w_1040_5785# w_1040_5785# sky130_fd_pr__pfet_g5v0d10v5 ad=0.98 pd=7.28 as=0.98 ps=7.28 w=7 l=0.5
X189 w_2676_441# a_1368_5960# w_1040_5785# w_2676_441# sky130_fd_pr__nfet_g5v0d10v5 ad=13.9 pd=41.39 as=15.1 ps=21.51 w=20 l=0.5
X190 w_2676_441# a_1368_5960# w_1040_5785# w_2676_441# sky130_fd_pr__nfet_g5v0d10v5 ad=13.9 pd=41.39 as=15.1 ps=21.51 w=20 l=0.5
X191 w_1040_5785# a_1368_5960# w_2676_441# w_2676_441# sky130_fd_pr__nfet_g5v0d10v5 ad=15.1 pd=21.51 as=13.9 ps=41.39 w=20 l=0.5
X192 w_2676_441# a_1368_5960# w_1040_5785# w_2676_441# sky130_fd_pr__nfet_g5v0d10v5 ad=6.95 pd=21.39 as=7.55 ps=11.51 w=10 l=0.5
X193 w_2676_441# a_1368_5960# w_1040_5785# w_2676_441# sky130_fd_pr__nfet_g5v0d10v5 ad=13.9 pd=41.39 as=15.1 ps=21.51 w=20 l=0.5
X194 w_2676_441# a_1368_5960# w_1040_5785# w_2676_441# sky130_fd_pr__nfet_g5v0d10v5 ad=13.9 pd=41.39 as=15.1 ps=21.51 w=20 l=0.5
X195 w_1040_5785# a_1368_5960# w_2676_441# w_2676_441# sky130_fd_pr__nfet_g5v0d10v5 ad=15.1 pd=21.51 as=13.9 ps=41.39 w=20 l=0.5
X196 w_2676_441# a_1368_5960# w_1040_5785# w_2676_441# sky130_fd_pr__nfet_g5v0d10v5 ad=13.9 pd=41.39 as=15.1 ps=21.51 w=20 l=0.5
X197 w_2676_441# a_1368_5960# w_1040_5785# w_2676_441# sky130_fd_pr__nfet_g5v0d10v5 ad=13.9 pd=41.39 as=15.1 ps=21.51 w=20 l=0.5
X198 w_1040_5785# a_1368_5960# w_2676_441# w_2676_441# sky130_fd_pr__nfet_g5v0d10v5 ad=15.1 pd=21.51 as=13.9 ps=41.39 w=20 l=0.5
X199 w_2676_441# a_1368_5960# w_1040_5785# w_2676_441# sky130_fd_pr__nfet_g5v0d10v5 ad=13.9 pd=41.39 as=15.1 ps=21.51 w=20 l=0.5
X200 w_2676_441# a_1368_5960# w_1040_5785# w_2676_441# sky130_fd_pr__nfet_g5v0d10v5 ad=13.9 pd=41.39 as=15.1 ps=21.51 w=20 l=0.5
X201 w_2676_441# a_1368_5960# w_1040_5785# w_2676_441# sky130_fd_pr__nfet_g5v0d10v5 ad=13.9 pd=41.39 as=15.1 ps=21.51 w=20 l=0.5
X202 w_2676_441# a_1368_5960# w_1040_5785# w_2676_441# sky130_fd_pr__nfet_g5v0d10v5 ad=13.9 pd=41.39 as=15.1 ps=21.51 w=20 l=0.5
X203 w_1040_5785# a_1368_5960# w_2676_441# w_2676_441# sky130_fd_pr__nfet_g5v0d10v5 ad=7.55 pd=11.51 as=6.95 ps=21.39 w=10 l=0.5
X204 w_2676_441# a_1368_5960# w_1040_5785# w_2676_441# sky130_fd_pr__nfet_g5v0d10v5 ad=13.9 pd=41.39 as=15.1 ps=21.51 w=20 l=0.5
X205 a_1368_5960# a_1268_5934# w_2676_441# w_2676_441# sky130_fd_pr__nfet_g5v0d10v5 ad=1.855 pd=14.53 as=0.98 ps=7.28 w=7 l=0.5
X206 a_1368_5960# a_1268_5934# w_1040_5785# w_1040_5785# sky130_fd_pr__pfet_g5v0d10v5 ad=0.98 pd=7.28 as=0.98 ps=7.28 w=7 l=0.5
X207 w_2676_441# a_1268_5934# a_1368_5960# w_2676_441# sky130_fd_pr__nfet_g5v0d10v5 ad=0.98 pd=7.28 as=0.98 ps=7.28 w=7 l=0.5
X208 w_1040_5785# a_1268_5934# a_1368_5960# w_1040_5785# sky130_fd_pr__pfet_g5v0d10v5 ad=0.98 pd=7.28 as=0.98 ps=7.28 w=7 l=0.5
X209 w_1040_5785# a_1368_5960# w_2676_441# w_2676_441# sky130_fd_pr__nfet_g5v0d10v5 ad=15.1 pd=21.51 as=13.9 ps=41.39 w=20 l=0.5
X210 w_2676_441# a_1368_5960# w_1040_5785# w_2676_441# sky130_fd_pr__nfet_g5v0d10v5 ad=6.95 pd=21.39 as=7.55 ps=11.51 w=10 l=0.5
.ends

.subckt sky130_fd_io__top_power_hvc_wpadv2 DRN_HVC SRC_BDY_HVC OGC_HVC AMUXBUS_B VDDA
+ VSSIO_Q P_PAD PADISOL VDDIO_Q P_CORE PADISOR VCCHIB VCCD VSWITCH VDDIO VSSA VSSD
+ AMUXBUS_A VSSIO
Xsky130_fd_io__hvc_clampv2_0 OGC_HVC DRN_HVC P_PAD PADISOR PADISOL VDDIO_Q AMUXBUS_B
+ VSSIO_Q SRC_BDY_HVC VCCHIB VSSIO VDDA VDDIO P_CORE VSSD VSWITCH VSSA AMUXBUS_A VCCD
+ sky130_fd_io__hvc_clampv2
.ends

.subckt sky130_ef_io__vddio_hvc_pad DRN_HVC VDDIO_PAD VDDA VSSIO_Q VDDIO VSSIO VDDIO_Q
+ VSSD AMUXBUS_B VSSA AMUXBUS_A VSWITCH VCCHIB SRC_BDY_HVC VCCD
Xsky130_fd_io__top_power_hvc_wpadv2_2 DRN_HVC SRC_BDY_HVC VDDIO AMUXBUS_B VDDA VSSIO_Q
+ VDDIO_PAD VDDIO_Q VDDIO_Q VDDIO VDDIO_Q VCCHIB VCCD VSWITCH VDDIO VSSA VSSD AMUXBUS_A
+ VSSIO sky130_fd_io__top_power_hvc_wpadv2
.ends

.subckt sky130_fd_io__top_power_lvc_wpad VSSIO_Q VCCHIB VDDA VDDIO_Q P_PAD SRC_BDY_LVC1
+ SRC_BDY_LVC2 BDY2_B2B DRN_LVC2 DRN_LVC1 P_CORE PADISOR PADISOL OGC_LVC AMUXBUS_B
+ VSSIO VDDIO VSSD VSWITCH VSSA AMUXBUS_A VCCD
Xsky130_fd_io__com_busses_esd_0 VCCHIB P_PAD VSSD P_CORE AMUXBUS_A VCCD AMUXBUS_B
+ VDDIO VSSA VSSIO VSWITCH VDDA VSSIO_Q VDDIO_Q sky130_fd_io__com_busses_esd
X0 SRC_BDY_LVC2 a_2872_5340# DRN_LVC2 SRC_BDY_LVC2 sky130_fd_pr__nfet_01v8 ad=3.5 pd=15 as=3.535 ps=8.01 w=7 l=0.18
X1 DRN_LVC1 a_450_404# SRC_BDY_LVC1 SRC_BDY_LVC1 sky130_fd_pr__nfet_01v8 ad=3.535 pd=8.01 as=3.5 ps=15 w=7 l=0.18
X2 SRC_BDY_LVC1 a_450_404# DRN_LVC1 SRC_BDY_LVC1 sky130_fd_pr__nfet_01v8 ad=3.5 pd=15 as=3.535 ps=8.01 w=7 l=0.18
X3 SRC_BDY_LVC2 a_2595_15129# SRC_BDY_LVC2 SRC_BDY_LVC2 sky130_fd_pr__nfet_01v8 ad=0.7 pd=5.28 as=0 ps=0 w=5 l=8
X4 DRN_LVC2 a_2872_5340# SRC_BDY_LVC2 SRC_BDY_LVC2 sky130_fd_pr__nfet_01v8 ad=3.535 pd=8.01 as=3.5 ps=15 w=7 l=0.18
X5 DRN_LVC2 a_2872_5340# SRC_BDY_LVC2 SRC_BDY_LVC2 sky130_fd_pr__nfet_01v8 ad=3.535 pd=8.01 as=3.5 ps=15 w=7 l=0.18
X6 SRC_BDY_LVC2 a_2872_5340# DRN_LVC2 SRC_BDY_LVC2 sky130_fd_pr__nfet_01v8 ad=3.5 pd=15 as=3.535 ps=8.01 w=7 l=0.18
X7 DRN_LVC1 a_414_306# a_450_404# DRN_LVC1 sky130_fd_pr__pfet_01v8 ad=0.98 pd=7.28 as=0.98 ps=7.28 w=7 l=0.18
X8 DRN_LVC2 a_2872_5340# SRC_BDY_LVC2 SRC_BDY_LVC2 sky130_fd_pr__nfet_01v8 ad=3.535 pd=8.01 as=3.5 ps=15 w=7 l=0.18
X9 SRC_BDY_LVC2 a_2872_5340# DRN_LVC2 SRC_BDY_LVC2 sky130_fd_pr__nfet_01v8 ad=3.5 pd=15 as=3.535 ps=8.01 w=7 l=0.18
X10 a_2872_5340# a_2595_15129# DRN_LVC2 DRN_LVC2 sky130_fd_pr__pfet_01v8 ad=0.98 pd=7.28 as=0.98 ps=7.28 w=7 l=0.18
X11 SRC_BDY_LVC1 a_414_306# SRC_BDY_LVC1 SRC_BDY_LVC1 sky130_fd_pr__nfet_01v8 ad=0.98 pd=7.28 as=0 ps=0 w=7 l=8
X12 SRC_BDY_LVC1 a_450_404# DRN_LVC1 SRC_BDY_LVC1 sky130_fd_pr__nfet_01v8 ad=5.625 pd=12.25 as=2.925 ps=6.17 w=5 l=0.18
X13 SRC_BDY_LVC2 a_2872_5340# DRN_LVC2 SRC_BDY_LVC2 sky130_fd_pr__nfet_01v8 ad=3.5 pd=15 as=3.535 ps=8.01 w=7 l=0.18
X14 DRN_LVC1 a_450_404# SRC_BDY_LVC1 SRC_BDY_LVC1 sky130_fd_pr__nfet_01v8 ad=4.095 pd=8.17 as=7.875 ps=16.25 w=7 l=0.18
X15 SRC_BDY_LVC1 a_450_404# DRN_LVC1 SRC_BDY_LVC1 sky130_fd_pr__nfet_01v8 ad=7.875 pd=16.25 as=4.095 ps=8.17 w=7 l=0.18
X16 SRC_BDY_LVC2 a_2595_15129# a_2872_5340# SRC_BDY_LVC2 sky130_fd_pr__nfet_01v8 ad=2.3975 pd=7.685 as=4.76 ps=15.36 w=7 l=0.18
X17 SRC_BDY_LVC2 a_2872_5340# DRN_LVC2 SRC_BDY_LVC2 sky130_fd_pr__nfet_01v8 ad=3.5 pd=15 as=3.535 ps=8.01 w=7 l=0.18
X18 DRN_LVC1 a_450_404# SRC_BDY_LVC1 SRC_BDY_LVC1 sky130_fd_pr__nfet_01v8 ad=4.095 pd=8.17 as=7.875 ps=16.25 w=7 l=0.18
X19 SRC_BDY_LVC2 a_2872_5340# DRN_LVC2 SRC_BDY_LVC2 sky130_fd_pr__nfet_01v8 ad=2.5 pd=11 as=2.525 ps=6.01 w=5 l=0.18
X20 DRN_LVC1 a_450_404# SRC_BDY_LVC1 SRC_BDY_LVC1 sky130_fd_pr__nfet_01v8 ad=2.925 pd=6.17 as=5.625 ps=12.25 w=5 l=0.18
X21 SRC_BDY_LVC2 a_2872_5340# DRN_LVC2 SRC_BDY_LVC2 sky130_fd_pr__nfet_01v8 ad=3.5 pd=15 as=3.535 ps=8.01 w=7 l=0.18
X22 SRC_BDY_LVC1 a_450_404# DRN_LVC1 SRC_BDY_LVC1 sky130_fd_pr__nfet_01v8 ad=7.875 pd=16.25 as=4.095 ps=8.17 w=7 l=0.18
X23 SRC_BDY_LVC1 a_450_404# DRN_LVC1 SRC_BDY_LVC1 sky130_fd_pr__nfet_01v8 ad=3.5 pd=15 as=3.535 ps=8.01 w=7 l=0.18
X24 a_450_404# a_414_306# DRN_LVC1 DRN_LVC1 sky130_fd_pr__pfet_01v8 ad=0.98 pd=7.28 as=0.98 ps=7.28 w=7 l=0.18
X25 SRC_BDY_LVC2 a_2872_5340# DRN_LVC2 SRC_BDY_LVC2 sky130_fd_pr__nfet_01v8 ad=3.5 pd=15 as=3.535 ps=8.01 w=7 l=0.18
X26 DRN_LVC1 a_450_404# SRC_BDY_LVC1 SRC_BDY_LVC1 sky130_fd_pr__nfet_01v8 ad=4.095 pd=8.17 as=7.875 ps=16.25 w=7 l=0.18
X27 DRN_LVC2 a_2872_5340# SRC_BDY_LVC2 SRC_BDY_LVC2 sky130_fd_pr__nfet_01v8 ad=3.535 pd=8.01 as=3.5 ps=15 w=7 l=0.18
X28 DRN_LVC2 a_2872_5340# SRC_BDY_LVC2 SRC_BDY_LVC2 sky130_fd_pr__nfet_01v8 ad=3.535 pd=8.01 as=3.5 ps=15 w=7 l=0.18
X29 DRN_LVC1 a_450_404# SRC_BDY_LVC1 SRC_BDY_LVC1 sky130_fd_pr__nfet_01v8 ad=2.925 pd=6.17 as=5.625 ps=12.25 w=5 l=0.18
X30 SRC_BDY_LVC1 a_450_404# DRN_LVC1 SRC_BDY_LVC1 sky130_fd_pr__nfet_01v8 ad=3.5 pd=15 as=3.535 ps=8.01 w=7 l=0.18
X31 DRN_LVC2 a_2872_5340# SRC_BDY_LVC2 SRC_BDY_LVC2 sky130_fd_pr__nfet_01v8 ad=3.535 pd=8.01 as=3.5 ps=15 w=7 l=0.18
X32 DRN_LVC1 a_450_404# SRC_BDY_LVC1 SRC_BDY_LVC1 sky130_fd_pr__nfet_01v8 ad=4.095 pd=8.17 as=7.875 ps=16.25 w=7 l=0.18
X33 SRC_BDY_LVC2 a_2872_5340# DRN_LVC2 SRC_BDY_LVC2 sky130_fd_pr__nfet_01v8 ad=3.5 pd=15 as=3.535 ps=8.01 w=7 l=0.18
X34 DRN_LVC1 a_450_404# SRC_BDY_LVC1 SRC_BDY_LVC1 sky130_fd_pr__nfet_01v8 ad=3.535 pd=8.01 as=3.5 ps=15 w=7 l=0.18
X35 SRC_BDY_LVC2 a_2872_5340# DRN_LVC2 SRC_BDY_LVC2 sky130_fd_pr__nfet_01v8 ad=3.5 pd=15 as=3.535 ps=8.01 w=7 l=0.18
X36 DRN_LVC1 a_414_306# a_450_404# DRN_LVC1 sky130_fd_pr__pfet_01v8 ad=0.98 pd=7.28 as=0.98 ps=7.28 w=7 l=0.18
X37 DRN_LVC2 a_2872_5340# SRC_BDY_LVC2 SRC_BDY_LVC2 sky130_fd_pr__nfet_01v8 ad=3.535 pd=8.01 as=3.5 ps=15 w=7 l=0.18
X38 SRC_BDY_LVC2 a_2872_5340# DRN_LVC2 SRC_BDY_LVC2 sky130_fd_pr__nfet_01v8 ad=3.5 pd=15 as=3.535 ps=8.01 w=7 l=0.18
X39 SRC_BDY_LVC2 a_2595_15129# SRC_BDY_LVC2 SRC_BDY_LVC2 sky130_fd_pr__nfet_01v8 ad=2.3975 pd=7.685 as=0 ps=0 w=7 l=8
X40 DRN_LVC1 a_414_306# a_450_404# DRN_LVC1 sky130_fd_pr__pfet_01v8 ad=0.98 pd=7.28 as=0.98 ps=7.28 w=7 l=0.18
X41 SRC_BDY_LVC1 a_414_306# SRC_BDY_LVC1 SRC_BDY_LVC1 sky130_fd_pr__nfet_01v8 ad=0.98 pd=7.28 as=0 ps=0 w=7 l=8
X42 SRC_BDY_LVC1 a_450_404# DRN_LVC1 SRC_BDY_LVC1 sky130_fd_pr__nfet_01v8 ad=7.875 pd=16.25 as=4.095 ps=8.17 w=7 l=0.18
X43 DRN_LVC2 a_2872_5340# SRC_BDY_LVC2 SRC_BDY_LVC2 sky130_fd_pr__nfet_01v8 ad=3.535 pd=8.01 as=3.5 ps=15 w=7 l=0.18
X44 SRC_BDY_LVC2 a_2872_5340# DRN_LVC2 SRC_BDY_LVC2 sky130_fd_pr__nfet_01v8 ad=3.5 pd=15 as=3.535 ps=8.01 w=7 l=0.18
X45 SRC_BDY_LVC1 a_450_404# DRN_LVC1 SRC_BDY_LVC1 sky130_fd_pr__nfet_01v8 ad=5.625 pd=12.25 as=2.925 ps=6.17 w=5 l=0.18
X46 a_450_404# a_414_306# DRN_LVC1 DRN_LVC1 sky130_fd_pr__pfet_01v8 ad=0.98 pd=7.28 as=1.96 ps=14.56 w=7 l=0.18
X47 DRN_LVC1 a_450_404# SRC_BDY_LVC1 SRC_BDY_LVC1 sky130_fd_pr__nfet_01v8 ad=4.095 pd=8.17 as=7.875 ps=16.25 w=7 l=0.18
X48 SRC_BDY_LVC1 a_450_404# DRN_LVC1 SRC_BDY_LVC1 sky130_fd_pr__nfet_01v8 ad=7.875 pd=16.25 as=4.095 ps=8.17 w=7 l=0.18
X49 a_414_306# DRN_LVC1 sky130_fd_pr__res_generic_po w=0.33 l=1.95k
X50 DRN_LVC1 a_450_404# SRC_BDY_LVC1 SRC_BDY_LVC1 sky130_fd_pr__nfet_01v8 ad=4.095 pd=8.17 as=7.875 ps=16.25 w=7 l=0.18
X51 DRN_LVC1 a_450_404# SRC_BDY_LVC1 SRC_BDY_LVC1 sky130_fd_pr__nfet_01v8 ad=2.925 pd=6.17 as=5.625 ps=12.25 w=5 l=0.18
X52 DRN_LVC2 a_2872_5340# SRC_BDY_LVC2 SRC_BDY_LVC2 sky130_fd_pr__nfet_01v8 ad=3.535 pd=8.01 as=3.5 ps=15 w=7 l=0.18
X53 SRC_BDY_LVC2 a_2872_5340# DRN_LVC2 SRC_BDY_LVC2 sky130_fd_pr__nfet_01v8 ad=3.5 pd=15 as=3.535 ps=8.01 w=7 l=0.18
X54 SRC_BDY_LVC1 a_450_404# DRN_LVC1 SRC_BDY_LVC1 sky130_fd_pr__nfet_01v8 ad=7.875 pd=16.25 as=4.095 ps=8.17 w=7 l=0.18
X55 SRC_BDY_LVC1 a_450_404# DRN_LVC1 SRC_BDY_LVC1 sky130_fd_pr__nfet_01v8 ad=3.5 pd=15 as=3.535 ps=8.01 w=7 l=0.18
X56 DRN_LVC1 a_450_404# SRC_BDY_LVC1 SRC_BDY_LVC1 sky130_fd_pr__nfet_01v8 ad=3.535 pd=8.01 as=3.5 ps=15 w=7 l=0.18
X57 SRC_BDY_LVC1 a_450_404# DRN_LVC1 SRC_BDY_LVC1 sky130_fd_pr__nfet_01v8 ad=7.875 pd=16.25 as=4.095 ps=8.17 w=7 l=0.18
X58 DRN_LVC2 a_2872_5340# SRC_BDY_LVC2 SRC_BDY_LVC2 sky130_fd_pr__nfet_01v8 ad=3.535 pd=8.01 as=3.5 ps=15 w=7 l=0.18
X59 a_450_404# a_414_306# DRN_LVC1 DRN_LVC1 sky130_fd_pr__pfet_01v8 ad=0.98 pd=7.28 as=0.98 ps=7.28 w=7 l=0.18
X60 DRN_LVC2 a_2872_5340# SRC_BDY_LVC2 SRC_BDY_LVC2 sky130_fd_pr__nfet_01v8 ad=2.525 pd=6.01 as=2.5 ps=11 w=5 l=0.18
X61 DRN_LVC2 a_2872_5340# SRC_BDY_LVC2 SRC_BDY_LVC2 sky130_fd_pr__nfet_01v8 ad=3.535 pd=8.01 as=3.5 ps=15 w=7 l=0.18
X62 SRC_BDY_LVC2 a_2872_5340# DRN_LVC2 SRC_BDY_LVC2 sky130_fd_pr__nfet_01v8 ad=3.5 pd=15 as=3.535 ps=8.01 w=7 l=0.18
X63 DRN_LVC1 a_450_404# SRC_BDY_LVC1 SRC_BDY_LVC1 sky130_fd_pr__nfet_01v8 ad=4.095 pd=8.17 as=7.875 ps=16.25 w=7 l=0.18
X64 a_2183_16816# a_2595_15129# sky130_fd_pr__res_generic_po w=0.33 l=200
X65 SRC_BDY_LVC1 a_450_404# DRN_LVC1 SRC_BDY_LVC1 sky130_fd_pr__nfet_01v8 ad=3.5 pd=15 as=3.535 ps=8.01 w=7 l=0.18
X66 DRN_LVC2 a_2595_15129# a_2872_5340# DRN_LVC2 sky130_fd_pr__pfet_01v8 ad=0.98 pd=7.28 as=0.98 ps=7.28 w=7 l=0.18
X67 DRN_LVC2 a_2872_5340# SRC_BDY_LVC2 SRC_BDY_LVC2 sky130_fd_pr__nfet_01v8 ad=3.535 pd=8.01 as=3.5 ps=15 w=7 l=0.18
X68 DRN_LVC1 a_450_404# SRC_BDY_LVC1 SRC_BDY_LVC1 sky130_fd_pr__nfet_01v8 ad=4.095 pd=8.17 as=7.875 ps=16.25 w=7 l=0.18
X69 SRC_BDY_LVC2 a_2872_5340# DRN_LVC2 SRC_BDY_LVC2 sky130_fd_pr__nfet_01v8 ad=3.5 pd=15 as=3.535 ps=8.01 w=7 l=0.18
X70 SRC_BDY_LVC2 a_2595_15129# SRC_BDY_LVC2 SRC_BDY_LVC2 sky130_fd_pr__nfet_01v8 ad=0.98 pd=7.28 as=0 ps=0 w=7 l=8
X71 DRN_LVC1 a_450_404# SRC_BDY_LVC1 SRC_BDY_LVC1 sky130_fd_pr__nfet_01v8 ad=3.535 pd=8.01 as=3.5 ps=15 w=7 l=0.18
X72 SRC_BDY_LVC1 a_450_404# DRN_LVC1 SRC_BDY_LVC1 sky130_fd_pr__nfet_01v8 ad=7.875 pd=16.25 as=4.095 ps=8.17 w=7 l=0.18
X73 DRN_LVC2 a_2872_5340# SRC_BDY_LVC2 SRC_BDY_LVC2 sky130_fd_pr__nfet_01v8 ad=2.525 pd=6.01 as=2.5 ps=11 w=5 l=0.18
X74 SRC_BDY_LVC2 a_2872_5340# DRN_LVC2 SRC_BDY_LVC2 sky130_fd_pr__nfet_01v8 ad=3.5 pd=15 as=3.535 ps=8.01 w=7 l=0.18
X75 SRC_BDY_LVC2 a_2595_15129# SRC_BDY_LVC2 SRC_BDY_LVC2 sky130_fd_pr__nfet_01v8 ad=0.98 pd=7.28 as=0 ps=0 w=7 l=8
X76 SRC_BDY_LVC1 a_450_404# DRN_LVC1 SRC_BDY_LVC1 sky130_fd_pr__nfet_01v8 ad=5.625 pd=12.25 as=2.925 ps=6.17 w=5 l=0.18
X77 SRC_BDY_LVC1 a_450_404# DRN_LVC1 SRC_BDY_LVC1 sky130_fd_pr__nfet_01v8 ad=7.875 pd=16.25 as=4.095 ps=8.17 w=7 l=0.18
X78 SRC_BDY_LVC2 a_2872_5340# DRN_LVC2 SRC_BDY_LVC2 sky130_fd_pr__nfet_01v8 ad=3.5 pd=15 as=3.535 ps=8.01 w=7 l=0.18
X79 DRN_LVC1 a_450_404# SRC_BDY_LVC1 SRC_BDY_LVC1 sky130_fd_pr__nfet_01v8 ad=4.095 pd=8.17 as=7.875 ps=16.25 w=7 l=0.18
X80 DRN_LVC2 a_2872_5340# SRC_BDY_LVC2 SRC_BDY_LVC2 sky130_fd_pr__nfet_01v8 ad=2.525 pd=6.01 as=2.5 ps=11 w=5 l=0.18
X81 SRC_BDY_LVC1 a_450_404# DRN_LVC1 SRC_BDY_LVC1 sky130_fd_pr__nfet_01v8 ad=3.5 pd=15 as=3.535 ps=8.01 w=7 l=0.18
X82 DRN_LVC2 a_2872_5340# SRC_BDY_LVC2 SRC_BDY_LVC2 sky130_fd_pr__nfet_01v8 ad=2.525 pd=6.01 as=2.5 ps=11 w=5 l=0.18
X83 SRC_BDY_LVC2 a_2872_5340# DRN_LVC2 SRC_BDY_LVC2 sky130_fd_pr__nfet_01v8 ad=2.5 pd=11 as=2.525 ps=6.01 w=5 l=0.18
X84 a_1871_4484# a_13955_3836# sky130_fd_pr__res_generic_po w=0.33 l=300
X85 DRN_LVC2 a_2595_15129# a_2872_5340# DRN_LVC2 sky130_fd_pr__pfet_01v8 ad=0.98 pd=7.28 as=0.98 ps=7.28 w=7 l=0.18
X86 DRN_LVC2 a_2872_5340# SRC_BDY_LVC2 SRC_BDY_LVC2 sky130_fd_pr__nfet_01v8 ad=2.525 pd=6.01 as=2.5 ps=11 w=5 l=0.18
X87 DRN_LVC2 a_2872_5340# SRC_BDY_LVC2 SRC_BDY_LVC2 sky130_fd_pr__nfet_01v8 ad=3.535 pd=8.01 as=3.5 ps=15 w=7 l=0.18
X88 DRN_LVC2 a_2872_5340# SRC_BDY_LVC2 SRC_BDY_LVC2 sky130_fd_pr__nfet_01v8 ad=3.535 pd=8.01 as=3.5 ps=15 w=7 l=0.18
X89 SRC_BDY_LVC2 a_2595_15129# SRC_BDY_LVC2 SRC_BDY_LVC2 sky130_fd_pr__nfet_01v8 ad=0.7 pd=5.28 as=0 ps=0 w=5 l=8
X90 DRN_LVC1 a_450_404# SRC_BDY_LVC1 SRC_BDY_LVC1 sky130_fd_pr__nfet_01v8 ad=4.095 pd=8.17 as=7.875 ps=16.25 w=7 l=0.18
X91 SRC_BDY_LVC1 a_450_404# DRN_LVC1 SRC_BDY_LVC1 sky130_fd_pr__nfet_01v8 ad=7.875 pd=16.25 as=4.095 ps=8.17 w=7 l=0.18
X92 DRN_LVC2 a_2872_5340# SRC_BDY_LVC2 SRC_BDY_LVC2 sky130_fd_pr__nfet_01v8 ad=3.535 pd=8.01 as=3.5 ps=15 w=7 l=0.18
X93 DRN_LVC1 a_450_404# SRC_BDY_LVC1 SRC_BDY_LVC1 sky130_fd_pr__nfet_01v8 ad=3.535 pd=8.01 as=3.5 ps=15 w=7 l=0.18
X94 SRC_BDY_LVC2 a_2872_5340# DRN_LVC2 SRC_BDY_LVC2 sky130_fd_pr__nfet_01v8 ad=2.5 pd=11 as=2.525 ps=6.01 w=5 l=0.18
X95 SRC_BDY_LVC1 a_450_404# DRN_LVC1 SRC_BDY_LVC1 sky130_fd_pr__nfet_01v8 ad=3.5 pd=15 as=3.535 ps=8.01 w=7 l=0.18
X96 DRN_LVC2 a_2872_5340# SRC_BDY_LVC2 SRC_BDY_LVC2 sky130_fd_pr__nfet_01v8 ad=3.535 pd=8.01 as=3.5 ps=15 w=7 l=0.18
X97 SRC_BDY_LVC2 a_2872_5340# DRN_LVC2 SRC_BDY_LVC2 sky130_fd_pr__nfet_01v8 ad=3.5 pd=15 as=3.535 ps=8.01 w=7 l=0.18
X98 DRN_LVC2 a_2872_5340# SRC_BDY_LVC2 SRC_BDY_LVC2 sky130_fd_pr__nfet_01v8 ad=3.535 pd=8.01 as=3.5 ps=15 w=7 l=0.18
X99 SRC_BDY_LVC1 a_414_306# a_450_404# SRC_BDY_LVC1 sky130_fd_pr__nfet_01v8 ad=2.3975 pd=7.685 as=4.76 ps=15.36 w=7 l=0.18
X100 DRN_LVC2 a_2872_5340# SRC_BDY_LVC2 SRC_BDY_LVC2 sky130_fd_pr__nfet_01v8 ad=3.535 pd=8.01 as=3.5 ps=15 w=7 l=0.18
X101 SRC_BDY_LVC2 a_2872_5340# DRN_LVC2 SRC_BDY_LVC2 sky130_fd_pr__nfet_01v8 ad=3.5 pd=15 as=3.535 ps=8.01 w=7 l=0.18
X102 SRC_BDY_LVC1 a_414_306# SRC_BDY_LVC1 SRC_BDY_LVC1 sky130_fd_pr__nfet_01v8 ad=2.3975 pd=7.685 as=0 ps=0 w=7 l=8
X103 DRN_LVC1 a_450_404# SRC_BDY_LVC1 SRC_BDY_LVC1 sky130_fd_pr__nfet_01v8 ad=3.535 pd=8.01 as=3.5 ps=15 w=7 l=0.18
X104 DRN_LVC1 a_450_404# SRC_BDY_LVC1 SRC_BDY_LVC1 sky130_fd_pr__nfet_01v8 ad=2.925 pd=6.17 as=5.625 ps=12.25 w=5 l=0.18
X105 DRN_LVC2 a_2872_5340# SRC_BDY_LVC2 SRC_BDY_LVC2 sky130_fd_pr__nfet_01v8 ad=3.535 pd=8.01 as=3.5 ps=15 w=7 l=0.18
X106 SRC_BDY_LVC2 a_2872_5340# DRN_LVC2 SRC_BDY_LVC2 sky130_fd_pr__nfet_01v8 ad=2.5 pd=11 as=2.525 ps=6.01 w=5 l=0.18
X107 DRN_LVC2 a_2595_15129# a_2872_5340# DRN_LVC2 sky130_fd_pr__pfet_01v8 ad=0.98 pd=7.28 as=0.98 ps=7.28 w=7 l=0.18
X108 SRC_BDY_LVC2 a_2872_5340# DRN_LVC2 SRC_BDY_LVC2 sky130_fd_pr__nfet_01v8 ad=3.5 pd=15 as=3.535 ps=8.01 w=7 l=0.18
X109 SRC_BDY_LVC2 a_2872_5340# DRN_LVC2 SRC_BDY_LVC2 sky130_fd_pr__nfet_01v8 ad=2.5 pd=11 as=2.525 ps=6.01 w=5 l=0.18
X110 DRN_LVC1 a_450_404# SRC_BDY_LVC1 SRC_BDY_LVC1 sky130_fd_pr__nfet_01v8 ad=3.535 pd=8.01 as=3.5 ps=15 w=7 l=0.18
X111 DRN_LVC2 a_2872_5340# SRC_BDY_LVC2 SRC_BDY_LVC2 sky130_fd_pr__nfet_01v8 ad=3.535 pd=8.01 as=3.5 ps=15 w=7 l=0.18
X112 SRC_BDY_LVC1 a_450_404# DRN_LVC1 SRC_BDY_LVC1 sky130_fd_pr__nfet_01v8 ad=7.875 pd=16.25 as=4.095 ps=8.17 w=7 l=0.18
X113 SRC_BDY_LVC1 BDY2_B2B sky130_fd_pr__diode_pd2nw_05v5 perim=3.3e+07 area=2.25e+13
X114 DRN_LVC2 a_2872_5340# SRC_BDY_LVC2 SRC_BDY_LVC2 sky130_fd_pr__nfet_01v8 ad=3.535 pd=8.01 as=3.5 ps=15 w=7 l=0.18
X115 SRC_BDY_LVC1 a_450_404# DRN_LVC1 SRC_BDY_LVC1 sky130_fd_pr__nfet_01v8 ad=7.875 pd=16.25 as=4.095 ps=8.17 w=7 l=0.18
X116 DRN_LVC2 a_2872_5340# SRC_BDY_LVC2 SRC_BDY_LVC2 sky130_fd_pr__nfet_01v8 ad=2.525 pd=6.01 as=2.5 ps=11 w=5 l=0.18
X117 DRN_LVC2 a_2872_5340# SRC_BDY_LVC2 SRC_BDY_LVC2 sky130_fd_pr__nfet_01v8 ad=3.535 pd=8.01 as=3.5 ps=15 w=7 l=0.18
X118 DRN_LVC1 a_450_404# SRC_BDY_LVC1 SRC_BDY_LVC1 sky130_fd_pr__nfet_01v8 ad=4.095 pd=8.17 as=7.875 ps=16.25 w=7 l=0.18
X119 SRC_BDY_LVC1 a_450_404# DRN_LVC1 SRC_BDY_LVC1 sky130_fd_pr__nfet_01v8 ad=3.5 pd=15 as=3.535 ps=8.01 w=7 l=0.18
X120 a_2872_5340# a_2595_15129# DRN_LVC2 DRN_LVC2 sky130_fd_pr__pfet_01v8 ad=0.98 pd=7.28 as=0.98 ps=7.28 w=7 l=0.18
X121 DRN_LVC1 a_450_404# SRC_BDY_LVC1 SRC_BDY_LVC1 sky130_fd_pr__nfet_01v8 ad=4.095 pd=8.17 as=7.875 ps=16.25 w=7 l=0.18
X122 SRC_BDY_LVC2 a_2872_5340# DRN_LVC2 SRC_BDY_LVC2 sky130_fd_pr__nfet_01v8 ad=3.5 pd=15 as=3.535 ps=8.01 w=7 l=0.18
X123 DRN_LVC2 a_2872_5340# SRC_BDY_LVC2 SRC_BDY_LVC2 sky130_fd_pr__nfet_01v8 ad=3.535 pd=8.01 as=3.5 ps=15 w=7 l=0.18
X124 BDY2_B2B SRC_BDY_LVC1 sky130_fd_pr__diode_pd2nw_05v5 perim=3.3e+07 area=2.25e+13
X125 SRC_BDY_LVC2 a_2872_5340# DRN_LVC2 SRC_BDY_LVC2 sky130_fd_pr__nfet_01v8 ad=3.5 pd=15 as=3.535 ps=8.01 w=7 l=0.18
X126 DRN_LVC2 a_2872_5340# SRC_BDY_LVC2 SRC_BDY_LVC2 sky130_fd_pr__nfet_01v8 ad=3.535 pd=8.01 as=3.5 ps=15 w=7 l=0.18
X127 DRN_LVC1 a_450_404# SRC_BDY_LVC1 SRC_BDY_LVC1 sky130_fd_pr__nfet_01v8 ad=4.095 pd=8.17 as=7.875 ps=16.25 w=7 l=0.18
X128 DRN_LVC2 a_2872_5340# SRC_BDY_LVC2 SRC_BDY_LVC2 sky130_fd_pr__nfet_01v8 ad=3.535 pd=8.01 as=3.5 ps=15 w=7 l=0.18
X129 DRN_LVC2 a_2872_5340# SRC_BDY_LVC2 SRC_BDY_LVC2 sky130_fd_pr__nfet_01v8 ad=3.535 pd=8.01 as=3.5 ps=15 w=7 l=0.18
X130 DRN_LVC2 a_2872_5340# SRC_BDY_LVC2 SRC_BDY_LVC2 sky130_fd_pr__nfet_01v8 ad=3.535 pd=8.01 as=3.5 ps=15 w=7 l=0.18
X131 SRC_BDY_LVC2 a_2872_5340# DRN_LVC2 SRC_BDY_LVC2 sky130_fd_pr__nfet_01v8 ad=3.5 pd=15 as=3.535 ps=8.01 w=7 l=0.18
X132 SRC_BDY_LVC2 a_2595_15129# SRC_BDY_LVC2 SRC_BDY_LVC2 sky130_fd_pr__nfet_01v8 ad=0.98 pd=7.28 as=0 ps=0 w=7 l=8
X133 SRC_BDY_LVC1 a_450_404# DRN_LVC1 SRC_BDY_LVC1 sky130_fd_pr__nfet_01v8 ad=3.5 pd=15 as=3.535 ps=8.01 w=7 l=0.18
X134 DRN_LVC1 a_450_404# SRC_BDY_LVC1 SRC_BDY_LVC1 sky130_fd_pr__nfet_01v8 ad=2.925 pd=6.17 as=5.625 ps=12.25 w=5 l=0.18
X135 DRN_LVC1 a_450_404# SRC_BDY_LVC1 SRC_BDY_LVC1 sky130_fd_pr__nfet_01v8 ad=4.095 pd=8.17 as=7.875 ps=16.25 w=7 l=0.18
X136 DRN_LVC2 a_2872_5340# SRC_BDY_LVC2 SRC_BDY_LVC2 sky130_fd_pr__nfet_01v8 ad=3.535 pd=8.01 as=3.5 ps=15 w=7 l=0.18
X137 SRC_BDY_LVC1 a_450_404# DRN_LVC1 SRC_BDY_LVC1 sky130_fd_pr__nfet_01v8 ad=3.5 pd=15 as=3.535 ps=8.01 w=7 l=0.18
X138 DRN_LVC2 a_2872_5340# SRC_BDY_LVC2 SRC_BDY_LVC2 sky130_fd_pr__nfet_01v8 ad=3.535 pd=8.01 as=3.5 ps=15 w=7 l=0.18
X139 SRC_BDY_LVC2 a_2872_5340# DRN_LVC2 SRC_BDY_LVC2 sky130_fd_pr__nfet_01v8 ad=3.5 pd=15 as=3.535 ps=8.01 w=7 l=0.18
X140 SRC_BDY_LVC2 a_2872_5340# DRN_LVC2 SRC_BDY_LVC2 sky130_fd_pr__nfet_01v8 ad=3.5 pd=15 as=3.535 ps=8.01 w=7 l=0.18
X141 SRC_BDY_LVC1 a_414_306# SRC_BDY_LVC1 SRC_BDY_LVC1 sky130_fd_pr__nfet_01v8 ad=2.3975 pd=7.685 as=0 ps=0 w=7 l=8
X142 SRC_BDY_LVC2 a_2872_5340# DRN_LVC2 SRC_BDY_LVC2 sky130_fd_pr__nfet_01v8 ad=3.5 pd=15 as=3.535 ps=8.01 w=7 l=0.18
X143 DRN_LVC1 a_450_404# SRC_BDY_LVC1 SRC_BDY_LVC1 sky130_fd_pr__nfet_01v8 ad=4.095 pd=8.17 as=7.875 ps=16.25 w=7 l=0.18
X144 a_2872_5340# a_2595_15129# DRN_LVC2 DRN_LVC2 sky130_fd_pr__pfet_01v8 ad=0.98 pd=7.28 as=1.96 ps=14.56 w=7 l=0.18
X145 SRC_BDY_LVC1 a_414_306# SRC_BDY_LVC1 SRC_BDY_LVC1 sky130_fd_pr__nfet_01v8 ad=0.98 pd=7.28 as=0 ps=0 w=7 l=8
X146 DRN_LVC1 a_450_404# SRC_BDY_LVC1 SRC_BDY_LVC1 sky130_fd_pr__nfet_01v8 ad=3.535 pd=8.01 as=3.5 ps=15 w=7 l=0.18
X147 SRC_BDY_LVC2 a_2872_5340# DRN_LVC2 SRC_BDY_LVC2 sky130_fd_pr__nfet_01v8 ad=3.5 pd=15 as=3.535 ps=8.01 w=7 l=0.18
X148 SRC_BDY_LVC2 a_2872_5340# DRN_LVC2 SRC_BDY_LVC2 sky130_fd_pr__nfet_01v8 ad=3.5 pd=15 as=3.535 ps=8.01 w=7 l=0.18
X149 SRC_BDY_LVC2 a_2872_5340# DRN_LVC2 SRC_BDY_LVC2 sky130_fd_pr__nfet_01v8 ad=3.5 pd=15 as=3.535 ps=8.01 w=7 l=0.18
X150 DRN_LVC1 a_450_404# SRC_BDY_LVC1 SRC_BDY_LVC1 sky130_fd_pr__nfet_01v8 ad=4.095 pd=8.17 as=7.875 ps=16.25 w=7 l=0.18
X151 SRC_BDY_LVC1 a_450_404# DRN_LVC1 SRC_BDY_LVC1 sky130_fd_pr__nfet_01v8 ad=5.625 pd=12.25 as=2.925 ps=6.17 w=5 l=0.18
X152 DRN_LVC2 a_2872_5340# SRC_BDY_LVC2 SRC_BDY_LVC2 sky130_fd_pr__nfet_01v8 ad=3.535 pd=8.01 as=3.5 ps=15 w=7 l=0.18
X153 SRC_BDY_LVC1 a_450_404# DRN_LVC1 SRC_BDY_LVC1 sky130_fd_pr__nfet_01v8 ad=7.875 pd=16.25 as=4.095 ps=8.17 w=7 l=0.18
X154 SRC_BDY_LVC1 a_450_404# DRN_LVC1 SRC_BDY_LVC1 sky130_fd_pr__nfet_01v8 ad=7.875 pd=16.25 as=4.095 ps=8.17 w=7 l=0.18
X155 DRN_LVC2 a_2872_5340# SRC_BDY_LVC2 SRC_BDY_LVC2 sky130_fd_pr__nfet_01v8 ad=3.535 pd=8.01 as=3.5 ps=15 w=7 l=0.18
X156 SRC_BDY_LVC2 a_2872_5340# DRN_LVC2 SRC_BDY_LVC2 sky130_fd_pr__nfet_01v8 ad=3.5 pd=15 as=3.535 ps=8.01 w=7 l=0.18
X157 DRN_LVC1 a_450_404# SRC_BDY_LVC1 SRC_BDY_LVC1 sky130_fd_pr__nfet_01v8 ad=4.095 pd=8.17 as=7.875 ps=16.25 w=7 l=0.18
X158 SRC_BDY_LVC1 a_414_306# SRC_BDY_LVC1 SRC_BDY_LVC1 sky130_fd_pr__nfet_01v8 ad=0.98 pd=7.28 as=0 ps=0 w=7 l=8
X159 DRN_LVC2 a_2872_5340# SRC_BDY_LVC2 SRC_BDY_LVC2 sky130_fd_pr__nfet_01v8 ad=3.535 pd=8.01 as=3.5 ps=15 w=7 l=0.18
X160 DRN_LVC1 a_450_404# SRC_BDY_LVC1 SRC_BDY_LVC1 sky130_fd_pr__nfet_01v8 ad=4.095 pd=8.17 as=7.875 ps=16.25 w=7 l=0.18
X161 DRN_LVC1 a_450_404# SRC_BDY_LVC1 SRC_BDY_LVC1 sky130_fd_pr__nfet_01v8 ad=4.095 pd=8.17 as=7.875 ps=16.25 w=7 l=0.18
X162 DRN_LVC2 a_2872_5340# SRC_BDY_LVC2 SRC_BDY_LVC2 sky130_fd_pr__nfet_01v8 ad=3.535 pd=8.01 as=3.5 ps=15 w=7 l=0.18
X163 SRC_BDY_LVC1 a_450_404# DRN_LVC1 SRC_BDY_LVC1 sky130_fd_pr__nfet_01v8 ad=3.5 pd=15 as=3.535 ps=8.01 w=7 l=0.18
X164 SRC_BDY_LVC2 a_2872_5340# DRN_LVC2 SRC_BDY_LVC2 sky130_fd_pr__nfet_01v8 ad=3.5 pd=15 as=3.535 ps=8.01 w=7 l=0.18
X165 DRN_LVC2 a_2872_5340# SRC_BDY_LVC2 SRC_BDY_LVC2 sky130_fd_pr__nfet_01v8 ad=3.535 pd=8.01 as=3.5 ps=15 w=7 l=0.18
X166 SRC_BDY_LVC2 a_2872_5340# DRN_LVC2 SRC_BDY_LVC2 sky130_fd_pr__nfet_01v8 ad=2.5 pd=11 as=2.525 ps=6.01 w=5 l=0.18
X167 DRN_LVC1 a_414_306# a_450_404# DRN_LVC1 sky130_fd_pr__pfet_01v8 ad=0.98 pd=7.28 as=0.98 ps=7.28 w=7 l=0.18
X168 DRN_LVC2 a_2872_5340# SRC_BDY_LVC2 SRC_BDY_LVC2 sky130_fd_pr__nfet_01v8 ad=3.535 pd=8.01 as=3.5 ps=15 w=7 l=0.18
X169 SRC_BDY_LVC1 a_450_404# DRN_LVC1 SRC_BDY_LVC1 sky130_fd_pr__nfet_01v8 ad=7.875 pd=16.25 as=4.095 ps=8.17 w=7 l=0.18
X170 SRC_BDY_LVC2 a_2872_5340# DRN_LVC2 SRC_BDY_LVC2 sky130_fd_pr__nfet_01v8 ad=3.5 pd=15 as=3.535 ps=8.01 w=7 l=0.18
X171 DRN_LVC1 a_450_404# SRC_BDY_LVC1 SRC_BDY_LVC1 sky130_fd_pr__nfet_01v8 ad=3.535 pd=8.01 as=3.5 ps=15 w=7 l=0.18
X172 DRN_LVC2 a_2595_15129# a_2872_5340# DRN_LVC2 sky130_fd_pr__pfet_01v8 ad=0.98 pd=7.28 as=0.98 ps=7.28 w=7 l=0.18
X173 SRC_BDY_LVC1 a_414_306# SRC_BDY_LVC1 SRC_BDY_LVC1 sky130_fd_pr__nfet_01v8 ad=0.98 pd=7.28 as=0 ps=0 w=7 l=8
X174 DRN_LVC1 a_450_404# SRC_BDY_LVC1 SRC_BDY_LVC1 sky130_fd_pr__nfet_01v8 ad=4.095 pd=8.17 as=7.875 ps=16.25 w=7 l=0.18
X175 a_450_404# a_414_306# DRN_LVC1 DRN_LVC1 sky130_fd_pr__pfet_01v8 ad=0.98 pd=7.28 as=0.98 ps=7.28 w=7 l=0.18
X176 SRC_BDY_LVC2 a_2872_5340# DRN_LVC2 SRC_BDY_LVC2 sky130_fd_pr__nfet_01v8 ad=2.5 pd=11 as=2.525 ps=6.01 w=5 l=0.18
X177 DRN_LVC2 a_2872_5340# SRC_BDY_LVC2 SRC_BDY_LVC2 sky130_fd_pr__nfet_01v8 ad=3.535 pd=8.01 as=3.5 ps=15 w=7 l=0.18
X178 DRN_LVC1 a_450_404# SRC_BDY_LVC1 SRC_BDY_LVC1 sky130_fd_pr__nfet_01v8 ad=3.535 pd=8.01 as=3.5 ps=15 w=7 l=0.18
X179 DRN_LVC1 a_450_404# SRC_BDY_LVC1 SRC_BDY_LVC1 sky130_fd_pr__nfet_01v8 ad=4.095 pd=8.17 as=7.875 ps=16.25 w=7 l=0.18
X180 SRC_BDY_LVC2 a_2872_5340# DRN_LVC2 SRC_BDY_LVC2 sky130_fd_pr__nfet_01v8 ad=3.5 pd=15 as=3.535 ps=8.01 w=7 l=0.18
X181 DRN_LVC1 a_414_306# a_450_404# DRN_LVC1 sky130_fd_pr__pfet_01v8 ad=0.98 pd=7.28 as=0.98 ps=7.28 w=7 l=0.18
X182 SRC_BDY_LVC1 a_450_404# DRN_LVC1 SRC_BDY_LVC1 sky130_fd_pr__nfet_01v8 ad=7.875 pd=16.25 as=4.095 ps=8.17 w=7 l=0.18
X183 DRN_LVC2 a_2872_5340# SRC_BDY_LVC2 SRC_BDY_LVC2 sky130_fd_pr__nfet_01v8 ad=3.535 pd=8.01 as=3.5 ps=15 w=7 l=0.18
X184 DRN_LVC2 a_2872_5340# SRC_BDY_LVC2 SRC_BDY_LVC2 sky130_fd_pr__nfet_01v8 ad=2.525 pd=6.01 as=2.5 ps=11 w=5 l=0.18
X185 DRN_LVC2 a_2872_5340# SRC_BDY_LVC2 SRC_BDY_LVC2 sky130_fd_pr__nfet_01v8 ad=3.535 pd=8.01 as=3.5 ps=15 w=7 l=0.18
X186 SRC_BDY_LVC2 a_2872_5340# DRN_LVC2 SRC_BDY_LVC2 sky130_fd_pr__nfet_01v8 ad=3.5 pd=15 as=3.535 ps=8.01 w=7 l=0.18
X187 SRC_BDY_LVC1 a_450_404# DRN_LVC1 SRC_BDY_LVC1 sky130_fd_pr__nfet_01v8 ad=7.875 pd=16.25 as=4.095 ps=8.17 w=7 l=0.18
X188 SRC_BDY_LVC1 a_414_306# SRC_BDY_LVC1 SRC_BDY_LVC1 sky130_fd_pr__nfet_01v8 ad=0.98 pd=7.28 as=0 ps=0 w=7 l=8
X189 DRN_LVC1 a_450_404# SRC_BDY_LVC1 SRC_BDY_LVC1 sky130_fd_pr__nfet_01v8 ad=3.535 pd=8.01 as=3.5 ps=15 w=7 l=0.18
X190 BDY2_B2B SRC_BDY_LVC1 sky130_fd_pr__diode_pd2nw_05v5 perim=3.3e+07 area=2.25e+13
X191 SRC_BDY_LVC1 a_450_404# DRN_LVC1 SRC_BDY_LVC1 sky130_fd_pr__nfet_01v8 ad=7.875 pd=16.25 as=4.095 ps=8.17 w=7 l=0.18
X192 DRN_LVC1 a_450_404# SRC_BDY_LVC1 SRC_BDY_LVC1 sky130_fd_pr__nfet_01v8 ad=3.535 pd=8.01 as=3.5 ps=15 w=7 l=0.18
X193 SRC_BDY_LVC2 a_2872_5340# DRN_LVC2 SRC_BDY_LVC2 sky130_fd_pr__nfet_01v8 ad=3.5 pd=15 as=3.535 ps=8.01 w=7 l=0.18
X194 SRC_BDY_LVC2 a_2595_15129# SRC_BDY_LVC2 SRC_BDY_LVC2 sky130_fd_pr__nfet_01v8 ad=0.98 pd=7.28 as=0 ps=0 w=7 l=8
X195 SRC_BDY_LVC1 a_450_404# DRN_LVC1 SRC_BDY_LVC1 sky130_fd_pr__nfet_01v8 ad=3.5 pd=15 as=3.535 ps=8.01 w=7 l=0.18
X196 DRN_LVC2 a_2872_5340# SRC_BDY_LVC2 SRC_BDY_LVC2 sky130_fd_pr__nfet_01v8 ad=3.535 pd=8.01 as=3.5 ps=15 w=7 l=0.18
X197 DRN_LVC1 a_450_404# SRC_BDY_LVC1 SRC_BDY_LVC1 sky130_fd_pr__nfet_01v8 ad=4.095 pd=8.17 as=7.875 ps=16.25 w=7 l=0.18
X198 DRN_LVC1 a_450_404# SRC_BDY_LVC1 SRC_BDY_LVC1 sky130_fd_pr__nfet_01v8 ad=3.535 pd=8.01 as=3.5 ps=15 w=7 l=0.18
X199 DRN_LVC2 a_2872_5340# SRC_BDY_LVC2 SRC_BDY_LVC2 sky130_fd_pr__nfet_01v8 ad=2.525 pd=6.01 as=2.5 ps=11 w=5 l=0.18
X200 SRC_BDY_LVC2 a_2872_5340# DRN_LVC2 SRC_BDY_LVC2 sky130_fd_pr__nfet_01v8 ad=3.5 pd=15 as=3.535 ps=8.01 w=7 l=0.18
X201 DRN_LVC2 a_2872_5340# SRC_BDY_LVC2 SRC_BDY_LVC2 sky130_fd_pr__nfet_01v8 ad=3.535 pd=8.01 as=3.5 ps=15 w=7 l=0.18
X202 SRC_BDY_LVC2 a_2872_5340# DRN_LVC2 SRC_BDY_LVC2 sky130_fd_pr__nfet_01v8 ad=3.5 pd=15 as=3.535 ps=8.01 w=7 l=0.18
X203 SRC_BDY_LVC2 a_2872_5340# DRN_LVC2 SRC_BDY_LVC2 sky130_fd_pr__nfet_01v8 ad=3.5 pd=15 as=3.535 ps=8.01 w=7 l=0.18
X204 DRN_LVC2 a_2872_5340# SRC_BDY_LVC2 SRC_BDY_LVC2 sky130_fd_pr__nfet_01v8 ad=2.525 pd=6.01 as=2.5 ps=11 w=5 l=0.18
X205 SRC_BDY_LVC1 a_450_404# DRN_LVC1 SRC_BDY_LVC1 sky130_fd_pr__nfet_01v8 ad=3.5 pd=15 as=3.535 ps=8.01 w=7 l=0.18
X206 SRC_BDY_LVC1 a_450_404# DRN_LVC1 SRC_BDY_LVC1 sky130_fd_pr__nfet_01v8 ad=7.875 pd=16.25 as=4.095 ps=8.17 w=7 l=0.18
X207 DRN_LVC1 a_450_404# SRC_BDY_LVC1 SRC_BDY_LVC1 sky130_fd_pr__nfet_01v8 ad=3.535 pd=8.01 as=3.5 ps=15 w=7 l=0.18
X208 DRN_LVC1 a_414_306# a_450_404# DRN_LVC1 sky130_fd_pr__pfet_01v8 ad=0.98 pd=7.28 as=0.98 ps=7.28 w=7 l=0.18
X209 DRN_LVC2 a_2872_5340# SRC_BDY_LVC2 SRC_BDY_LVC2 sky130_fd_pr__nfet_01v8 ad=2.525 pd=6.01 as=2.5 ps=11 w=5 l=0.18
X210 DRN_LVC1 a_450_404# SRC_BDY_LVC1 SRC_BDY_LVC1 sky130_fd_pr__nfet_01v8 ad=4.095 pd=8.17 as=7.875 ps=16.25 w=7 l=0.18
X211 SRC_BDY_LVC2 a_2595_15129# SRC_BDY_LVC2 SRC_BDY_LVC2 sky130_fd_pr__nfet_01v8 ad=0.7 pd=5.28 as=0 ps=0 w=5 l=8
X212 DRN_LVC2 a_2872_5340# SRC_BDY_LVC2 SRC_BDY_LVC2 sky130_fd_pr__nfet_01v8 ad=3.535 pd=8.01 as=3.5 ps=15 w=7 l=0.18
X213 SRC_BDY_LVC2 a_2872_5340# DRN_LVC2 SRC_BDY_LVC2 sky130_fd_pr__nfet_01v8 ad=3.5 pd=15 as=3.535 ps=8.01 w=7 l=0.18
X214 DRN_LVC1 a_450_404# SRC_BDY_LVC1 SRC_BDY_LVC1 sky130_fd_pr__nfet_01v8 ad=2.925 pd=6.17 as=5.625 ps=12.25 w=5 l=0.18
X215 SRC_BDY_LVC1 a_450_404# DRN_LVC1 SRC_BDY_LVC1 sky130_fd_pr__nfet_01v8 ad=3.5 pd=15 as=3.535 ps=8.01 w=7 l=0.18
X216 DRN_LVC1 a_414_306# a_450_404# DRN_LVC1 sky130_fd_pr__pfet_01v8 ad=1.96 pd=14.56 as=0.98 ps=7.28 w=7 l=0.18
X217 SRC_BDY_LVC2 a_2872_5340# DRN_LVC2 SRC_BDY_LVC2 sky130_fd_pr__nfet_01v8 ad=3.5 pd=15 as=3.535 ps=8.01 w=7 l=0.18
X218 SRC_BDY_LVC1 a_450_404# DRN_LVC1 SRC_BDY_LVC1 sky130_fd_pr__nfet_01v8 ad=3.5 pd=15 as=3.535 ps=8.01 w=7 l=0.18
X219 DRN_LVC1 a_450_404# SRC_BDY_LVC1 SRC_BDY_LVC1 sky130_fd_pr__nfet_01v8 ad=3.535 pd=8.01 as=3.5 ps=15 w=7 l=0.18
X220 SRC_BDY_LVC2 a_2872_5340# DRN_LVC2 SRC_BDY_LVC2 sky130_fd_pr__nfet_01v8 ad=3.5 pd=15 as=3.535 ps=8.01 w=7 l=0.18
X221 SRC_BDY_LVC1 a_450_404# DRN_LVC1 SRC_BDY_LVC1 sky130_fd_pr__nfet_01v8 ad=7.875 pd=16.25 as=4.095 ps=8.17 w=7 l=0.18
X222 SRC_BDY_LVC2 a_2872_5340# DRN_LVC2 SRC_BDY_LVC2 sky130_fd_pr__nfet_01v8 ad=2.5 pd=11 as=2.525 ps=6.01 w=5 l=0.18
X223 DRN_LVC2 a_2872_5340# SRC_BDY_LVC2 SRC_BDY_LVC2 sky130_fd_pr__nfet_01v8 ad=3.535 pd=8.01 as=3.5 ps=15 w=7 l=0.18
X224 DRN_LVC2 a_2872_5340# SRC_BDY_LVC2 SRC_BDY_LVC2 sky130_fd_pr__nfet_01v8 ad=3.535 pd=8.01 as=3.5 ps=15 w=7 l=0.18
X225 SRC_BDY_LVC1 a_414_306# SRC_BDY_LVC1 SRC_BDY_LVC1 sky130_fd_pr__nfet_01v8 ad=0.98 pd=7.28 as=0 ps=0 w=7 l=8
X226 SRC_BDY_LVC2 a_2872_5340# DRN_LVC2 SRC_BDY_LVC2 sky130_fd_pr__nfet_01v8 ad=3.5 pd=15 as=3.535 ps=8.01 w=7 l=0.18
X227 DRN_LVC2 a_2872_5340# SRC_BDY_LVC2 SRC_BDY_LVC2 sky130_fd_pr__nfet_01v8 ad=3.535 pd=8.01 as=3.5 ps=15 w=7 l=0.18
X228 DRN_LVC1 a_450_404# SRC_BDY_LVC1 SRC_BDY_LVC1 sky130_fd_pr__nfet_01v8 ad=3.535 pd=8.01 as=3.5 ps=15 w=7 l=0.18
X229 a_2872_5340# a_2595_15129# DRN_LVC2 DRN_LVC2 sky130_fd_pr__pfet_01v8 ad=0.98 pd=7.28 as=0.98 ps=7.28 w=7 l=0.18
X230 DRN_LVC1 a_450_404# SRC_BDY_LVC1 SRC_BDY_LVC1 sky130_fd_pr__nfet_01v8 ad=3.535 pd=8.01 as=3.5 ps=15 w=7 l=0.18
X231 DRN_LVC1 a_450_404# SRC_BDY_LVC1 SRC_BDY_LVC1 sky130_fd_pr__nfet_01v8 ad=3.535 pd=8.01 as=3.5 ps=15 w=7 l=0.18
X232 BDY2_B2B SRC_BDY_LVC1 sky130_fd_pr__diode_pd2nw_05v5 perim=3.3e+07 area=2.25e+13
X233 a_2872_5340# a_2595_15129# DRN_LVC2 DRN_LVC2 sky130_fd_pr__pfet_01v8 ad=0.98 pd=7.28 as=0.98 ps=7.28 w=7 l=0.18
X234 SRC_BDY_LVC1 a_450_404# DRN_LVC1 SRC_BDY_LVC1 sky130_fd_pr__nfet_01v8 ad=7.875 pd=16.25 as=4.095 ps=8.17 w=7 l=0.18
X235 SRC_BDY_LVC1 a_450_404# DRN_LVC1 SRC_BDY_LVC1 sky130_fd_pr__nfet_01v8 ad=3.5 pd=15 as=3.535 ps=8.01 w=7 l=0.18
X236 SRC_BDY_LVC2 a_2872_5340# DRN_LVC2 SRC_BDY_LVC2 sky130_fd_pr__nfet_01v8 ad=2.5 pd=11 as=2.525 ps=6.01 w=5 l=0.18
X237 DRN_LVC1 a_450_404# SRC_BDY_LVC1 SRC_BDY_LVC1 sky130_fd_pr__nfet_01v8 ad=3.535 pd=8.01 as=3.5 ps=15 w=7 l=0.18
X238 DRN_LVC2 a_2872_5340# SRC_BDY_LVC2 SRC_BDY_LVC2 sky130_fd_pr__nfet_01v8 ad=3.535 pd=8.01 as=3.5 ps=15 w=7 l=0.18
X239 DRN_LVC1 a_450_404# SRC_BDY_LVC1 SRC_BDY_LVC1 sky130_fd_pr__nfet_01v8 ad=4.095 pd=8.17 as=7.875 ps=16.25 w=7 l=0.18
X240 a_450_404# a_414_306# DRN_LVC1 DRN_LVC1 sky130_fd_pr__pfet_01v8 ad=0.98 pd=7.28 as=0.98 ps=7.28 w=7 l=0.18
X241 DRN_LVC2 a_2872_5340# SRC_BDY_LVC2 SRC_BDY_LVC2 sky130_fd_pr__nfet_01v8 ad=3.535 pd=8.01 as=3.5 ps=15 w=7 l=0.18
X242 SRC_BDY_LVC2 a_2872_5340# DRN_LVC2 SRC_BDY_LVC2 sky130_fd_pr__nfet_01v8 ad=3.5 pd=15 as=3.535 ps=8.01 w=7 l=0.18
X243 DRN_LVC1 a_450_404# SRC_BDY_LVC1 SRC_BDY_LVC1 sky130_fd_pr__nfet_01v8 ad=2.925 pd=6.17 as=5.625 ps=12.25 w=5 l=0.18
X244 a_450_404# a_414_306# DRN_LVC1 DRN_LVC1 sky130_fd_pr__pfet_01v8 ad=0.98 pd=7.28 as=0.98 ps=7.28 w=7 l=0.18
X245 SRC_BDY_LVC2 a_2872_5340# DRN_LVC2 SRC_BDY_LVC2 sky130_fd_pr__nfet_01v8 ad=2.5 pd=11 as=2.525 ps=6.01 w=5 l=0.18
X246 DRN_LVC2 a_2872_5340# SRC_BDY_LVC2 SRC_BDY_LVC2 sky130_fd_pr__nfet_01v8 ad=2.525 pd=6.01 as=2.5 ps=11 w=5 l=0.18
X247 DRN_LVC2 a_2872_5340# SRC_BDY_LVC2 SRC_BDY_LVC2 sky130_fd_pr__nfet_01v8 ad=3.535 pd=8.01 as=3.5 ps=15 w=7 l=0.18
X248 SRC_BDY_LVC1 a_450_404# DRN_LVC1 SRC_BDY_LVC1 sky130_fd_pr__nfet_01v8 ad=3.5 pd=15 as=3.535 ps=8.01 w=7 l=0.18
X249 SRC_BDY_LVC1 a_450_404# DRN_LVC1 SRC_BDY_LVC1 sky130_fd_pr__nfet_01v8 ad=7.875 pd=16.25 as=4.095 ps=8.17 w=7 l=0.18
X250 DRN_LVC2 a_2872_5340# SRC_BDY_LVC2 SRC_BDY_LVC2 sky130_fd_pr__nfet_01v8 ad=3.535 pd=8.01 as=3.5 ps=15 w=7 l=0.18
X251 DRN_LVC2 a_13955_3836# sky130_fd_pr__res_generic_po w=0.33 l=900
X252 DRN_LVC1 a_450_404# SRC_BDY_LVC1 SRC_BDY_LVC1 sky130_fd_pr__nfet_01v8 ad=4.095 pd=8.17 as=7.875 ps=16.25 w=7 l=0.18
X253 a_1871_4484# a_2183_16816# sky130_fd_pr__res_generic_po w=0.33 l=720
X254 DRN_LVC2 a_2872_5340# SRC_BDY_LVC2 SRC_BDY_LVC2 sky130_fd_pr__nfet_01v8 ad=3.535 pd=8.01 as=3.5 ps=15 w=7 l=0.18
X255 SRC_BDY_LVC1 a_450_404# DRN_LVC1 SRC_BDY_LVC1 sky130_fd_pr__nfet_01v8 ad=3.5 pd=15 as=3.535 ps=8.01 w=7 l=0.18
X256 DRN_LVC1 a_450_404# SRC_BDY_LVC1 SRC_BDY_LVC1 sky130_fd_pr__nfet_01v8 ad=4.095 pd=8.17 as=7.875 ps=16.25 w=7 l=0.18
X257 SRC_BDY_LVC2 a_2872_5340# DRN_LVC2 SRC_BDY_LVC2 sky130_fd_pr__nfet_01v8 ad=3.5 pd=15 as=3.535 ps=8.01 w=7 l=0.18
X258 SRC_BDY_LVC2 a_2872_5340# DRN_LVC2 SRC_BDY_LVC2 sky130_fd_pr__nfet_01v8 ad=3.5 pd=15 as=3.535 ps=8.01 w=7 l=0.18
X259 SRC_BDY_LVC1 a_450_404# DRN_LVC1 SRC_BDY_LVC1 sky130_fd_pr__nfet_01v8 ad=7.875 pd=16.25 as=4.095 ps=8.17 w=7 l=0.18
X260 DRN_LVC2 a_2872_5340# SRC_BDY_LVC2 SRC_BDY_LVC2 sky130_fd_pr__nfet_01v8 ad=3.535 pd=8.01 as=3.5 ps=15 w=7 l=0.18
X261 DRN_LVC2 a_2595_15129# a_2872_5340# DRN_LVC2 sky130_fd_pr__pfet_01v8 ad=1.96 pd=14.56 as=0.98 ps=7.28 w=7 l=0.18
X262 SRC_BDY_LVC2 a_2872_5340# DRN_LVC2 SRC_BDY_LVC2 sky130_fd_pr__nfet_01v8 ad=3.5 pd=15 as=3.535 ps=8.01 w=7 l=0.18
X263 SRC_BDY_LVC1 a_450_404# DRN_LVC1 SRC_BDY_LVC1 sky130_fd_pr__nfet_01v8 ad=7.875 pd=16.25 as=4.095 ps=8.17 w=7 l=0.18
X264 SRC_BDY_LVC2 a_2872_5340# DRN_LVC2 SRC_BDY_LVC2 sky130_fd_pr__nfet_01v8 ad=3.5 pd=15 as=3.535 ps=8.01 w=7 l=0.18
X265 DRN_LVC2 a_2872_5340# SRC_BDY_LVC2 SRC_BDY_LVC2 sky130_fd_pr__nfet_01v8 ad=3.535 pd=8.01 as=3.5 ps=15 w=7 l=0.18
X266 SRC_BDY_LVC1 a_450_404# DRN_LVC1 SRC_BDY_LVC1 sky130_fd_pr__nfet_01v8 ad=5.625 pd=12.25 as=2.925 ps=6.17 w=5 l=0.18
X267 DRN_LVC1 a_450_404# SRC_BDY_LVC1 SRC_BDY_LVC1 sky130_fd_pr__nfet_01v8 ad=3.535 pd=8.01 as=3.5 ps=15 w=7 l=0.18
X268 SRC_BDY_LVC1 a_450_404# DRN_LVC1 SRC_BDY_LVC1 sky130_fd_pr__nfet_01v8 ad=7.875 pd=16.25 as=4.095 ps=8.17 w=7 l=0.18
X269 SRC_BDY_LVC2 a_2872_5340# DRN_LVC2 SRC_BDY_LVC2 sky130_fd_pr__nfet_01v8 ad=3.5 pd=15 as=3.535 ps=8.01 w=7 l=0.18
X270 DRN_LVC1 a_450_404# SRC_BDY_LVC1 SRC_BDY_LVC1 sky130_fd_pr__nfet_01v8 ad=4.095 pd=8.17 as=7.875 ps=16.25 w=7 l=0.18
X271 a_2872_5340# a_2595_15129# DRN_LVC2 DRN_LVC2 sky130_fd_pr__pfet_01v8 ad=0.98 pd=7.28 as=0.98 ps=7.28 w=7 l=0.18
X272 SRC_BDY_LVC2 a_2872_5340# DRN_LVC2 SRC_BDY_LVC2 sky130_fd_pr__nfet_01v8 ad=3.5 pd=15 as=3.535 ps=8.01 w=7 l=0.18
X273 SRC_BDY_LVC1 a_450_404# DRN_LVC1 SRC_BDY_LVC1 sky130_fd_pr__nfet_01v8 ad=3.5 pd=15 as=3.535 ps=8.01 w=7 l=0.18
X274 SRC_BDY_LVC2 a_2595_15129# a_2872_5340# SRC_BDY_LVC2 sky130_fd_pr__nfet_01v8 ad=2.3975 pd=7.685 as=4.76 ps=15.36 w=7 l=0.18
X275 SRC_BDY_LVC2 a_2872_5340# DRN_LVC2 SRC_BDY_LVC2 sky130_fd_pr__nfet_01v8 ad=3.5 pd=15 as=3.535 ps=8.01 w=7 l=0.18
X276 DRN_LVC2 a_2872_5340# SRC_BDY_LVC2 SRC_BDY_LVC2 sky130_fd_pr__nfet_01v8 ad=3.535 pd=8.01 as=3.5 ps=15 w=7 l=0.18
X277 DRN_LVC2 a_2872_5340# SRC_BDY_LVC2 SRC_BDY_LVC2 sky130_fd_pr__nfet_01v8 ad=2.525 pd=6.01 as=2.5 ps=11 w=5 l=0.18
X278 DRN_LVC2 a_2872_5340# SRC_BDY_LVC2 SRC_BDY_LVC2 sky130_fd_pr__nfet_01v8 ad=3.535 pd=8.01 as=3.5 ps=15 w=7 l=0.18
X279 SRC_BDY_LVC1 a_414_306# SRC_BDY_LVC1 SRC_BDY_LVC1 sky130_fd_pr__nfet_01v8 ad=0.98 pd=7.28 as=0 ps=0 w=7 l=8
X280 SRC_BDY_LVC1 a_450_404# DRN_LVC1 SRC_BDY_LVC1 sky130_fd_pr__nfet_01v8 ad=7.875 pd=16.25 as=4.095 ps=8.17 w=7 l=0.18
X281 DRN_LVC2 a_2595_15129# a_2872_5340# DRN_LVC2 sky130_fd_pr__pfet_01v8 ad=0.98 pd=7.28 as=0.98 ps=7.28 w=7 l=0.18
X282 a_450_404# a_414_306# DRN_LVC1 DRN_LVC1 sky130_fd_pr__pfet_01v8 ad=0.98 pd=7.28 as=0.98 ps=7.28 w=7 l=0.18
X283 DRN_LVC2 a_2595_15129# a_2872_5340# DRN_LVC2 sky130_fd_pr__pfet_01v8 ad=0.98 pd=7.28 as=0.98 ps=7.28 w=7 l=0.18
X284 SRC_BDY_LVC1 a_450_404# DRN_LVC1 SRC_BDY_LVC1 sky130_fd_pr__nfet_01v8 ad=3.5 pd=15 as=3.535 ps=8.01 w=7 l=0.18
X285 SRC_BDY_LVC2 a_2595_15129# SRC_BDY_LVC2 SRC_BDY_LVC2 sky130_fd_pr__nfet_01v8 ad=2.3975 pd=7.685 as=0 ps=0 w=7 l=8
X286 SRC_BDY_LVC1 a_450_404# DRN_LVC1 SRC_BDY_LVC1 sky130_fd_pr__nfet_01v8 ad=5.625 pd=12.25 as=2.925 ps=6.17 w=5 l=0.18
X287 DRN_LVC1 a_450_404# SRC_BDY_LVC1 SRC_BDY_LVC1 sky130_fd_pr__nfet_01v8 ad=4.095 pd=8.17 as=7.875 ps=16.25 w=7 l=0.18
X288 SRC_BDY_LVC2 a_2872_5340# DRN_LVC2 SRC_BDY_LVC2 sky130_fd_pr__nfet_01v8 ad=3.5 pd=15 as=3.535 ps=8.01 w=7 l=0.18
X289 SRC_BDY_LVC2 a_2872_5340# DRN_LVC2 SRC_BDY_LVC2 sky130_fd_pr__nfet_01v8 ad=3.5 pd=15 as=3.535 ps=8.01 w=7 l=0.18
X290 SRC_BDY_LVC1 a_450_404# DRN_LVC1 SRC_BDY_LVC1 sky130_fd_pr__nfet_01v8 ad=7.875 pd=16.25 as=4.095 ps=8.17 w=7 l=0.18
X291 DRN_LVC1 a_450_404# SRC_BDY_LVC1 SRC_BDY_LVC1 sky130_fd_pr__nfet_01v8 ad=3.535 pd=8.01 as=3.5 ps=15 w=7 l=0.18
X292 SRC_BDY_LVC1 a_450_404# DRN_LVC1 SRC_BDY_LVC1 sky130_fd_pr__nfet_01v8 ad=7.875 pd=16.25 as=4.095 ps=8.17 w=7 l=0.18
X293 DRN_LVC2 a_2872_5340# SRC_BDY_LVC2 SRC_BDY_LVC2 sky130_fd_pr__nfet_01v8 ad=3.535 pd=8.01 as=3.5 ps=15 w=7 l=0.18
X294 DRN_LVC2 a_2595_15129# a_2872_5340# DRN_LVC2 sky130_fd_pr__pfet_01v8 ad=0.98 pd=7.28 as=0.98 ps=7.28 w=7 l=0.18
X295 SRC_BDY_LVC2 a_2872_5340# DRN_LVC2 SRC_BDY_LVC2 sky130_fd_pr__nfet_01v8 ad=2.5 pd=11 as=2.525 ps=6.01 w=5 l=0.18
X296 SRC_BDY_LVC1 BDY2_B2B sky130_fd_pr__diode_pd2nw_05v5 perim=3.3e+07 area=2.25e+13
X297 SRC_BDY_LVC1 a_450_404# DRN_LVC1 SRC_BDY_LVC1 sky130_fd_pr__nfet_01v8 ad=7.875 pd=16.25 as=4.095 ps=8.17 w=7 l=0.18
X298 DRN_LVC1 a_450_404# SRC_BDY_LVC1 SRC_BDY_LVC1 sky130_fd_pr__nfet_01v8 ad=3.535 pd=8.01 as=3.5 ps=15 w=7 l=0.18
X299 SRC_BDY_LVC2 a_2872_5340# DRN_LVC2 SRC_BDY_LVC2 sky130_fd_pr__nfet_01v8 ad=2.5 pd=11 as=2.525 ps=6.01 w=5 l=0.18
X300 SRC_BDY_LVC1 a_450_404# DRN_LVC1 SRC_BDY_LVC1 sky130_fd_pr__nfet_01v8 ad=3.5 pd=15 as=3.535 ps=8.01 w=7 l=0.18
X301 SRC_BDY_LVC2 a_2872_5340# DRN_LVC2 SRC_BDY_LVC2 sky130_fd_pr__nfet_01v8 ad=3.5 pd=15 as=3.535 ps=8.01 w=7 l=0.18
X302 DRN_LVC2 a_2872_5340# SRC_BDY_LVC2 SRC_BDY_LVC2 sky130_fd_pr__nfet_01v8 ad=3.535 pd=8.01 as=3.5 ps=15 w=7 l=0.18
X303 DRN_LVC1 a_450_404# SRC_BDY_LVC1 SRC_BDY_LVC1 sky130_fd_pr__nfet_01v8 ad=3.535 pd=8.01 as=3.5 ps=15 w=7 l=0.18
X304 DRN_LVC2 a_2872_5340# SRC_BDY_LVC2 SRC_BDY_LVC2 sky130_fd_pr__nfet_01v8 ad=3.535 pd=8.01 as=3.5 ps=15 w=7 l=0.18
X305 DRN_LVC1 a_450_404# SRC_BDY_LVC1 SRC_BDY_LVC1 sky130_fd_pr__nfet_01v8 ad=3.535 pd=8.01 as=3.5 ps=15 w=7 l=0.18
X306 DRN_LVC2 a_2872_5340# SRC_BDY_LVC2 SRC_BDY_LVC2 sky130_fd_pr__nfet_01v8 ad=2.525 pd=6.01 as=2.5 ps=11 w=5 l=0.18
X307 DRN_LVC1 a_450_404# SRC_BDY_LVC1 SRC_BDY_LVC1 sky130_fd_pr__nfet_01v8 ad=4.095 pd=8.17 as=7.875 ps=16.25 w=7 l=0.18
X308 SRC_BDY_LVC1 a_450_404# DRN_LVC1 SRC_BDY_LVC1 sky130_fd_pr__nfet_01v8 ad=7.875 pd=16.25 as=4.095 ps=8.17 w=7 l=0.18
X309 SRC_BDY_LVC1 a_450_404# DRN_LVC1 SRC_BDY_LVC1 sky130_fd_pr__nfet_01v8 ad=3.5 pd=15 as=3.535 ps=8.01 w=7 l=0.18
X310 SRC_BDY_LVC2 a_2595_15129# SRC_BDY_LVC2 SRC_BDY_LVC2 sky130_fd_pr__nfet_01v8 ad=0.98 pd=7.28 as=0 ps=0 w=7 l=8
X311 DRN_LVC1 a_450_404# SRC_BDY_LVC1 SRC_BDY_LVC1 sky130_fd_pr__nfet_01v8 ad=4.095 pd=8.17 as=7.875 ps=16.25 w=7 l=0.18
X312 SRC_BDY_LVC2 a_2872_5340# DRN_LVC2 SRC_BDY_LVC2 sky130_fd_pr__nfet_01v8 ad=3.5 pd=15 as=3.535 ps=8.01 w=7 l=0.18
X313 DRN_LVC2 a_2872_5340# SRC_BDY_LVC2 SRC_BDY_LVC2 sky130_fd_pr__nfet_01v8 ad=2.525 pd=6.01 as=2.5 ps=11 w=5 l=0.18
X314 SRC_BDY_LVC1 a_450_404# DRN_LVC1 SRC_BDY_LVC1 sky130_fd_pr__nfet_01v8 ad=3.5 pd=15 as=3.535 ps=8.01 w=7 l=0.18
X315 DRN_LVC1 a_450_404# SRC_BDY_LVC1 SRC_BDY_LVC1 sky130_fd_pr__nfet_01v8 ad=3.535 pd=8.01 as=3.5 ps=15 w=7 l=0.18
X316 SRC_BDY_LVC2 a_2595_15129# SRC_BDY_LVC2 SRC_BDY_LVC2 sky130_fd_pr__nfet_01v8 ad=0.7 pd=5.28 as=0 ps=0 w=5 l=8
X317 SRC_BDY_LVC2 a_2595_15129# SRC_BDY_LVC2 SRC_BDY_LVC2 sky130_fd_pr__nfet_01v8 ad=0.98 pd=7.28 as=0 ps=0 w=7 l=8
X318 SRC_BDY_LVC1 a_450_404# DRN_LVC1 SRC_BDY_LVC1 sky130_fd_pr__nfet_01v8 ad=5.625 pd=12.25 as=2.925 ps=6.17 w=5 l=0.18
X319 DRN_LVC1 a_414_306# a_450_404# DRN_LVC1 sky130_fd_pr__pfet_01v8 ad=1.96 pd=14.56 as=0.98 ps=7.28 w=7 l=0.18
X320 SRC_BDY_LVC2 a_2872_5340# DRN_LVC2 SRC_BDY_LVC2 sky130_fd_pr__nfet_01v8 ad=3.5 pd=15 as=3.535 ps=8.01 w=7 l=0.18
X321 DRN_LVC1 a_450_404# SRC_BDY_LVC1 SRC_BDY_LVC1 sky130_fd_pr__nfet_01v8 ad=4.095 pd=8.17 as=7.875 ps=16.25 w=7 l=0.18
X322 SRC_BDY_LVC1 a_414_306# a_450_404# SRC_BDY_LVC1 sky130_fd_pr__nfet_01v8 ad=2.3975 pd=7.685 as=4.76 ps=15.36 w=7 l=0.18
X323 a_2872_5340# a_2595_15129# DRN_LVC2 DRN_LVC2 sky130_fd_pr__pfet_01v8 ad=0.98 pd=7.28 as=1.96 ps=14.56 w=7 l=0.18
X324 SRC_BDY_LVC1 a_450_404# DRN_LVC1 SRC_BDY_LVC1 sky130_fd_pr__nfet_01v8 ad=3.5 pd=15 as=3.535 ps=8.01 w=7 l=0.18
X325 DRN_LVC2 a_2872_5340# SRC_BDY_LVC2 SRC_BDY_LVC2 sky130_fd_pr__nfet_01v8 ad=3.535 pd=8.01 as=3.5 ps=15 w=7 l=0.18
X326 DRN_LVC1 a_450_404# SRC_BDY_LVC1 SRC_BDY_LVC1 sky130_fd_pr__nfet_01v8 ad=3.535 pd=8.01 as=3.5 ps=15 w=7 l=0.18
X327 a_450_404# a_414_306# DRN_LVC1 DRN_LVC1 sky130_fd_pr__pfet_01v8 ad=0.98 pd=7.28 as=0.98 ps=7.28 w=7 l=0.18
X328 SRC_BDY_LVC2 a_2872_5340# DRN_LVC2 SRC_BDY_LVC2 sky130_fd_pr__nfet_01v8 ad=2.5 pd=11 as=2.525 ps=6.01 w=5 l=0.18
X329 DRN_LVC1 a_450_404# SRC_BDY_LVC1 SRC_BDY_LVC1 sky130_fd_pr__nfet_01v8 ad=2.925 pd=6.17 as=5.625 ps=12.25 w=5 l=0.18
X330 DRN_LVC2 a_2595_15129# a_2872_5340# DRN_LVC2 sky130_fd_pr__pfet_01v8 ad=1.96 pd=14.56 as=0.98 ps=7.28 w=7 l=0.18
X331 SRC_BDY_LVC2 a_2872_5340# DRN_LVC2 SRC_BDY_LVC2 sky130_fd_pr__nfet_01v8 ad=3.5 pd=15 as=3.535 ps=8.01 w=7 l=0.18
X332 DRN_LVC1 a_450_404# SRC_BDY_LVC1 SRC_BDY_LVC1 sky130_fd_pr__nfet_01v8 ad=4.095 pd=8.17 as=7.875 ps=16.25 w=7 l=0.18
X333 SRC_BDY_LVC2 a_2872_5340# DRN_LVC2 SRC_BDY_LVC2 sky130_fd_pr__nfet_01v8 ad=3.5 pd=15 as=3.535 ps=8.01 w=7 l=0.18
X334 DRN_LVC1 a_450_404# SRC_BDY_LVC1 SRC_BDY_LVC1 sky130_fd_pr__nfet_01v8 ad=3.535 pd=8.01 as=3.5 ps=15 w=7 l=0.18
X335 SRC_BDY_LVC1 a_450_404# DRN_LVC1 SRC_BDY_LVC1 sky130_fd_pr__nfet_01v8 ad=3.5 pd=15 as=3.535 ps=8.01 w=7 l=0.18
X336 DRN_LVC1 a_450_404# SRC_BDY_LVC1 SRC_BDY_LVC1 sky130_fd_pr__nfet_01v8 ad=3.535 pd=8.01 as=3.5 ps=15 w=7 l=0.18
X337 DRN_LVC2 a_2872_5340# SRC_BDY_LVC2 SRC_BDY_LVC2 sky130_fd_pr__nfet_01v8 ad=2.525 pd=6.01 as=2.5 ps=11 w=5 l=0.18
X338 DRN_LVC2 a_2872_5340# SRC_BDY_LVC2 SRC_BDY_LVC2 sky130_fd_pr__nfet_01v8 ad=3.535 pd=8.01 as=3.5 ps=15 w=7 l=0.18
X339 DRN_LVC1 a_450_404# SRC_BDY_LVC1 SRC_BDY_LVC1 sky130_fd_pr__nfet_01v8 ad=3.535 pd=8.01 as=3.5 ps=15 w=7 l=0.18
X340 SRC_BDY_LVC1 a_450_404# DRN_LVC1 SRC_BDY_LVC1 sky130_fd_pr__nfet_01v8 ad=7.875 pd=16.25 as=4.095 ps=8.17 w=7 l=0.18
X341 DRN_LVC1 a_450_404# SRC_BDY_LVC1 SRC_BDY_LVC1 sky130_fd_pr__nfet_01v8 ad=4.095 pd=8.17 as=7.875 ps=16.25 w=7 l=0.18
X342 DRN_LVC2 a_2872_5340# SRC_BDY_LVC2 SRC_BDY_LVC2 sky130_fd_pr__nfet_01v8 ad=3.535 pd=8.01 as=3.5 ps=15 w=7 l=0.18
X343 SRC_BDY_LVC1 a_450_404# DRN_LVC1 SRC_BDY_LVC1 sky130_fd_pr__nfet_01v8 ad=7.875 pd=16.25 as=4.095 ps=8.17 w=7 l=0.18
X344 SRC_BDY_LVC1 BDY2_B2B sky130_fd_pr__diode_pd2nw_05v5 perim=3.3e+07 area=2.25e+13
X345 SRC_BDY_LVC2 a_2872_5340# DRN_LVC2 SRC_BDY_LVC2 sky130_fd_pr__nfet_01v8 ad=2.5 pd=11 as=2.525 ps=6.01 w=5 l=0.18
X346 SRC_BDY_LVC1 a_450_404# DRN_LVC1 SRC_BDY_LVC1 sky130_fd_pr__nfet_01v8 ad=5.625 pd=12.25 as=2.925 ps=6.17 w=5 l=0.18
X347 DRN_LVC2 a_2872_5340# SRC_BDY_LVC2 SRC_BDY_LVC2 sky130_fd_pr__nfet_01v8 ad=3.535 pd=8.01 as=3.5 ps=15 w=7 l=0.18
X348 SRC_BDY_LVC2 a_2872_5340# DRN_LVC2 SRC_BDY_LVC2 sky130_fd_pr__nfet_01v8 ad=2.5 pd=11 as=2.525 ps=6.01 w=5 l=0.18
X349 DRN_LVC2 a_2872_5340# SRC_BDY_LVC2 SRC_BDY_LVC2 sky130_fd_pr__nfet_01v8 ad=3.535 pd=8.01 as=3.5 ps=15 w=7 l=0.18
X350 SRC_BDY_LVC1 a_450_404# DRN_LVC1 SRC_BDY_LVC1 sky130_fd_pr__nfet_01v8 ad=3.5 pd=15 as=3.535 ps=8.01 w=7 l=0.18
X351 SRC_BDY_LVC1 a_450_404# DRN_LVC1 SRC_BDY_LVC1 sky130_fd_pr__nfet_01v8 ad=7.875 pd=16.25 as=4.095 ps=8.17 w=7 l=0.18
X352 SRC_BDY_LVC1 a_414_306# a_450_404# SRC_BDY_LVC1 sky130_fd_pr__nfet_01v8 ad=2.3975 pd=7.685 as=4.76 ps=15.36 w=7 l=0.18
X353 SRC_BDY_LVC1 a_414_306# SRC_BDY_LVC1 SRC_BDY_LVC1 sky130_fd_pr__nfet_01v8 ad=2.3975 pd=7.685 as=0 ps=0 w=7 l=8
X354 SRC_BDY_LVC2 a_2595_15129# SRC_BDY_LVC2 SRC_BDY_LVC2 sky130_fd_pr__nfet_01v8 ad=0.98 pd=7.28 as=0 ps=0 w=7 l=8
X355 DRN_LVC1 a_414_306# a_450_404# DRN_LVC1 sky130_fd_pr__pfet_01v8 ad=0.98 pd=7.28 as=0.98 ps=7.28 w=7 l=0.18
X356 SRC_BDY_LVC1 a_450_404# DRN_LVC1 SRC_BDY_LVC1 sky130_fd_pr__nfet_01v8 ad=3.5 pd=15 as=3.535 ps=8.01 w=7 l=0.18
X357 DRN_LVC2 a_2872_5340# SRC_BDY_LVC2 SRC_BDY_LVC2 sky130_fd_pr__nfet_01v8 ad=3.535 pd=8.01 as=3.5 ps=15 w=7 l=0.18
X358 SRC_BDY_LVC2 a_2872_5340# DRN_LVC2 SRC_BDY_LVC2 sky130_fd_pr__nfet_01v8 ad=3.5 pd=15 as=3.535 ps=8.01 w=7 l=0.18
X359 SRC_BDY_LVC2 a_2872_5340# DRN_LVC2 SRC_BDY_LVC2 sky130_fd_pr__nfet_01v8 ad=3.5 pd=15 as=3.535 ps=8.01 w=7 l=0.18
X360 SRC_BDY_LVC2 a_2872_5340# DRN_LVC2 SRC_BDY_LVC2 sky130_fd_pr__nfet_01v8 ad=3.5 pd=15 as=3.535 ps=8.01 w=7 l=0.18
X361 DRN_LVC1 a_450_404# SRC_BDY_LVC1 SRC_BDY_LVC1 sky130_fd_pr__nfet_01v8 ad=4.095 pd=8.17 as=7.875 ps=16.25 w=7 l=0.18
X362 SRC_BDY_LVC1 a_450_404# DRN_LVC1 SRC_BDY_LVC1 sky130_fd_pr__nfet_01v8 ad=7.875 pd=16.25 as=4.095 ps=8.17 w=7 l=0.18
X363 DRN_LVC1 a_450_404# SRC_BDY_LVC1 SRC_BDY_LVC1 sky130_fd_pr__nfet_01v8 ad=3.535 pd=8.01 as=3.5 ps=15 w=7 l=0.18
X364 DRN_LVC1 a_450_404# SRC_BDY_LVC1 SRC_BDY_LVC1 sky130_fd_pr__nfet_01v8 ad=3.535 pd=8.01 as=3.5 ps=15 w=7 l=0.18
X365 SRC_BDY_LVC1 a_450_404# DRN_LVC1 SRC_BDY_LVC1 sky130_fd_pr__nfet_01v8 ad=3.5 pd=15 as=3.535 ps=8.01 w=7 l=0.18
X366 DRN_LVC2 a_2872_5340# SRC_BDY_LVC2 SRC_BDY_LVC2 sky130_fd_pr__nfet_01v8 ad=3.535 pd=8.01 as=3.5 ps=15 w=7 l=0.18
X367 SRC_BDY_LVC1 a_450_404# DRN_LVC1 SRC_BDY_LVC1 sky130_fd_pr__nfet_01v8 ad=7.875 pd=16.25 as=4.095 ps=8.17 w=7 l=0.18
X368 DRN_LVC1 a_450_404# SRC_BDY_LVC1 SRC_BDY_LVC1 sky130_fd_pr__nfet_01v8 ad=4.095 pd=8.17 as=7.875 ps=16.25 w=7 l=0.18
X369 SRC_BDY_LVC1 a_450_404# DRN_LVC1 SRC_BDY_LVC1 sky130_fd_pr__nfet_01v8 ad=7.875 pd=16.25 as=4.095 ps=8.17 w=7 l=0.18
X370 SRC_BDY_LVC2 a_2872_5340# DRN_LVC2 SRC_BDY_LVC2 sky130_fd_pr__nfet_01v8 ad=3.5 pd=15 as=3.535 ps=8.01 w=7 l=0.18
X371 SRC_BDY_LVC1 BDY2_B2B sky130_fd_pr__diode_pd2nw_05v5 perim=3.3e+07 area=2.25e+13
X372 SRC_BDY_LVC2 a_2872_5340# DRN_LVC2 SRC_BDY_LVC2 sky130_fd_pr__nfet_01v8 ad=3.5 pd=15 as=3.535 ps=8.01 w=7 l=0.18
X373 a_450_404# a_414_306# DRN_LVC1 DRN_LVC1 sky130_fd_pr__pfet_01v8 ad=0.98 pd=7.28 as=1.96 ps=14.56 w=7 l=0.18
X374 DRN_LVC2 a_2872_5340# SRC_BDY_LVC2 SRC_BDY_LVC2 sky130_fd_pr__nfet_01v8 ad=3.535 pd=8.01 as=3.5 ps=15 w=7 l=0.18
X375 SRC_BDY_LVC1 a_414_306# SRC_BDY_LVC1 SRC_BDY_LVC1 sky130_fd_pr__nfet_01v8 ad=0.98 pd=7.28 as=0 ps=0 w=7 l=8
R0 P_CORE PADISOL sky130_fd_pr__res_generic_m3 w=12.245 l=10m
X376 SRC_BDY_LVC2 a_2872_5340# DRN_LVC2 SRC_BDY_LVC2 sky130_fd_pr__nfet_01v8 ad=3.5 pd=15 as=3.535 ps=8.01 w=7 l=0.18
X377 DRN_LVC2 a_2872_5340# SRC_BDY_LVC2 SRC_BDY_LVC2 sky130_fd_pr__nfet_01v8 ad=2.525 pd=6.01 as=2.5 ps=11 w=5 l=0.18
X378 DRN_LVC1 a_450_404# SRC_BDY_LVC1 SRC_BDY_LVC1 sky130_fd_pr__nfet_01v8 ad=4.095 pd=8.17 as=7.875 ps=16.25 w=7 l=0.18
X379 SRC_BDY_LVC1 a_450_404# DRN_LVC1 SRC_BDY_LVC1 sky130_fd_pr__nfet_01v8 ad=7.875 pd=16.25 as=4.095 ps=8.17 w=7 l=0.18
X380 SRC_BDY_LVC1 a_414_306# SRC_BDY_LVC1 SRC_BDY_LVC1 sky130_fd_pr__nfet_01v8 ad=0.98 pd=7.28 as=0 ps=0 w=7 l=8
X381 SRC_BDY_LVC1 a_450_404# DRN_LVC1 SRC_BDY_LVC1 sky130_fd_pr__nfet_01v8 ad=3.5 pd=15 as=3.535 ps=8.01 w=7 l=0.18
X382 SRC_BDY_LVC2 a_2872_5340# DRN_LVC2 SRC_BDY_LVC2 sky130_fd_pr__nfet_01v8 ad=3.5 pd=15 as=3.535 ps=8.01 w=7 l=0.18
X383 DRN_LVC2 a_2872_5340# SRC_BDY_LVC2 SRC_BDY_LVC2 sky130_fd_pr__nfet_01v8 ad=3.535 pd=8.01 as=3.5 ps=15 w=7 l=0.18
X384 SRC_BDY_LVC1 a_450_404# DRN_LVC1 SRC_BDY_LVC1 sky130_fd_pr__nfet_01v8 ad=5.625 pd=12.25 as=2.925 ps=6.17 w=5 l=0.18
X385 SRC_BDY_LVC1 a_450_404# DRN_LVC1 SRC_BDY_LVC1 sky130_fd_pr__nfet_01v8 ad=3.5 pd=15 as=3.535 ps=8.01 w=7 l=0.18
X386 SRC_BDY_LVC2 a_2872_5340# DRN_LVC2 SRC_BDY_LVC2 sky130_fd_pr__nfet_01v8 ad=3.5 pd=15 as=3.535 ps=8.01 w=7 l=0.18
X387 DRN_LVC2 a_2872_5340# SRC_BDY_LVC2 SRC_BDY_LVC2 sky130_fd_pr__nfet_01v8 ad=3.535 pd=8.01 as=3.5 ps=15 w=7 l=0.18
X388 SRC_BDY_LVC2 a_2872_5340# DRN_LVC2 SRC_BDY_LVC2 sky130_fd_pr__nfet_01v8 ad=2.5 pd=11 as=2.525 ps=6.01 w=5 l=0.18
X389 SRC_BDY_LVC2 a_2595_15129# SRC_BDY_LVC2 SRC_BDY_LVC2 sky130_fd_pr__nfet_01v8 ad=0.7 pd=5.28 as=0 ps=0 w=5 l=8
X390 DRN_LVC2 a_2872_5340# SRC_BDY_LVC2 SRC_BDY_LVC2 sky130_fd_pr__nfet_01v8 ad=3.535 pd=8.01 as=3.5 ps=15 w=7 l=0.18
X391 SRC_BDY_LVC1 a_450_404# DRN_LVC1 SRC_BDY_LVC1 sky130_fd_pr__nfet_01v8 ad=7.875 pd=16.25 as=4.095 ps=8.17 w=7 l=0.18
X392 DRN_LVC1 a_450_404# SRC_BDY_LVC1 SRC_BDY_LVC1 sky130_fd_pr__nfet_01v8 ad=4.095 pd=8.17 as=7.875 ps=16.25 w=7 l=0.18
X393 DRN_LVC1 a_450_404# SRC_BDY_LVC1 SRC_BDY_LVC1 sky130_fd_pr__nfet_01v8 ad=3.535 pd=8.01 as=3.5 ps=15 w=7 l=0.18
X394 SRC_BDY_LVC1 a_450_404# DRN_LVC1 SRC_BDY_LVC1 sky130_fd_pr__nfet_01v8 ad=7.875 pd=16.25 as=4.095 ps=8.17 w=7 l=0.18
X395 SRC_BDY_LVC2 a_2872_5340# DRN_LVC2 SRC_BDY_LVC2 sky130_fd_pr__nfet_01v8 ad=3.5 pd=15 as=3.535 ps=8.01 w=7 l=0.18
X396 SRC_BDY_LVC1 a_414_306# SRC_BDY_LVC1 SRC_BDY_LVC1 sky130_fd_pr__nfet_01v8 ad=0.98 pd=7.28 as=0 ps=0 w=7 l=8
X397 SRC_BDY_LVC2 a_2872_5340# DRN_LVC2 SRC_BDY_LVC2 sky130_fd_pr__nfet_01v8 ad=2.5 pd=11 as=2.525 ps=6.01 w=5 l=0.18
X398 DRN_LVC1 a_450_404# SRC_BDY_LVC1 SRC_BDY_LVC1 sky130_fd_pr__nfet_01v8 ad=4.095 pd=8.17 as=7.875 ps=16.25 w=7 l=0.18
X399 DRN_LVC2 a_2872_5340# SRC_BDY_LVC2 SRC_BDY_LVC2 sky130_fd_pr__nfet_01v8 ad=3.535 pd=8.01 as=3.5 ps=15 w=7 l=0.18
X400 DRN_LVC2 a_2872_5340# SRC_BDY_LVC2 SRC_BDY_LVC2 sky130_fd_pr__nfet_01v8 ad=3.535 pd=8.01 as=3.5 ps=15 w=7 l=0.18
X401 DRN_LVC1 a_450_404# SRC_BDY_LVC1 SRC_BDY_LVC1 sky130_fd_pr__nfet_01v8 ad=3.535 pd=8.01 as=3.5 ps=15 w=7 l=0.18
X402 a_2872_5340# a_2595_15129# DRN_LVC2 DRN_LVC2 sky130_fd_pr__pfet_01v8 ad=0.98 pd=7.28 as=0.98 ps=7.28 w=7 l=0.18
X403 a_2872_5340# a_2595_15129# DRN_LVC2 DRN_LVC2 sky130_fd_pr__pfet_01v8 ad=0.98 pd=7.28 as=0.98 ps=7.28 w=7 l=0.18
X404 DRN_LVC1 a_450_404# SRC_BDY_LVC1 SRC_BDY_LVC1 sky130_fd_pr__nfet_01v8 ad=4.095 pd=8.17 as=7.875 ps=16.25 w=7 l=0.18
X405 SRC_BDY_LVC1 a_450_404# DRN_LVC1 SRC_BDY_LVC1 sky130_fd_pr__nfet_01v8 ad=7.875 pd=16.25 as=4.095 ps=8.17 w=7 l=0.18
X406 SRC_BDY_LVC1 a_450_404# DRN_LVC1 SRC_BDY_LVC1 sky130_fd_pr__nfet_01v8 ad=3.5 pd=15 as=3.535 ps=8.01 w=7 l=0.18
X407 SRC_BDY_LVC1 a_450_404# DRN_LVC1 SRC_BDY_LVC1 sky130_fd_pr__nfet_01v8 ad=5.625 pd=12.25 as=2.925 ps=6.17 w=5 l=0.18
X408 SRC_BDY_LVC2 a_2872_5340# DRN_LVC2 SRC_BDY_LVC2 sky130_fd_pr__nfet_01v8 ad=3.5 pd=15 as=3.535 ps=8.01 w=7 l=0.18
X409 DRN_LVC1 a_450_404# SRC_BDY_LVC1 SRC_BDY_LVC1 sky130_fd_pr__nfet_01v8 ad=4.095 pd=8.17 as=7.875 ps=16.25 w=7 l=0.18
X410 a_450_404# a_414_306# DRN_LVC1 DRN_LVC1 sky130_fd_pr__pfet_01v8 ad=0.98 pd=7.28 as=0.98 ps=7.28 w=7 l=0.18
X411 a_2872_5340# a_2595_15129# DRN_LVC2 DRN_LVC2 sky130_fd_pr__pfet_01v8 ad=0.98 pd=7.28 as=0.98 ps=7.28 w=7 l=0.18
X412 SRC_BDY_LVC2 a_2872_5340# DRN_LVC2 SRC_BDY_LVC2 sky130_fd_pr__nfet_01v8 ad=3.5 pd=15 as=3.535 ps=8.01 w=7 l=0.18
X413 DRN_LVC1 a_450_404# SRC_BDY_LVC1 SRC_BDY_LVC1 sky130_fd_pr__nfet_01v8 ad=4.095 pd=8.17 as=7.875 ps=16.25 w=7 l=0.18
X414 SRC_BDY_LVC1 a_450_404# DRN_LVC1 SRC_BDY_LVC1 sky130_fd_pr__nfet_01v8 ad=3.5 pd=15 as=3.535 ps=8.01 w=7 l=0.18
X415 SRC_BDY_LVC1 a_450_404# DRN_LVC1 SRC_BDY_LVC1 sky130_fd_pr__nfet_01v8 ad=3.5 pd=15 as=3.535 ps=8.01 w=7 l=0.18
X416 SRC_BDY_LVC2 a_2872_5340# DRN_LVC2 SRC_BDY_LVC2 sky130_fd_pr__nfet_01v8 ad=3.5 pd=15 as=3.535 ps=8.01 w=7 l=0.18
X417 DRN_LVC2 a_2872_5340# SRC_BDY_LVC2 SRC_BDY_LVC2 sky130_fd_pr__nfet_01v8 ad=3.535 pd=8.01 as=3.5 ps=15 w=7 l=0.18
X418 SRC_BDY_LVC2 a_2872_5340# DRN_LVC2 SRC_BDY_LVC2 sky130_fd_pr__nfet_01v8 ad=3.5 pd=15 as=3.535 ps=8.01 w=7 l=0.18
X419 SRC_BDY_LVC2 a_2595_15129# SRC_BDY_LVC2 SRC_BDY_LVC2 sky130_fd_pr__nfet_01v8 ad=0.98 pd=7.28 as=0 ps=0 w=7 l=8
X420 SRC_BDY_LVC1 a_414_306# SRC_BDY_LVC1 SRC_BDY_LVC1 sky130_fd_pr__nfet_01v8 ad=0.98 pd=7.28 as=0 ps=0 w=7 l=8
X421 DRN_LVC1 a_450_404# SRC_BDY_LVC1 SRC_BDY_LVC1 sky130_fd_pr__nfet_01v8 ad=3.535 pd=8.01 as=3.5 ps=15 w=7 l=0.18
X422 DRN_LVC2 a_2872_5340# SRC_BDY_LVC2 SRC_BDY_LVC2 sky130_fd_pr__nfet_01v8 ad=3.535 pd=8.01 as=3.5 ps=15 w=7 l=0.18
X423 SRC_BDY_LVC2 a_2872_5340# DRN_LVC2 SRC_BDY_LVC2 sky130_fd_pr__nfet_01v8 ad=3.5 pd=15 as=3.535 ps=8.01 w=7 l=0.18
X424 DRN_LVC2 a_2872_5340# SRC_BDY_LVC2 SRC_BDY_LVC2 sky130_fd_pr__nfet_01v8 ad=2.525 pd=6.01 as=2.5 ps=11 w=5 l=0.18
X425 SRC_BDY_LVC2 a_2595_15129# SRC_BDY_LVC2 SRC_BDY_LVC2 sky130_fd_pr__nfet_01v8 ad=0.7 pd=5.28 as=0 ps=0 w=5 l=8
X426 SRC_BDY_LVC1 a_450_404# DRN_LVC1 SRC_BDY_LVC1 sky130_fd_pr__nfet_01v8 ad=7.875 pd=16.25 as=4.095 ps=8.17 w=7 l=0.18
X427 SRC_BDY_LVC1 a_450_404# DRN_LVC1 SRC_BDY_LVC1 sky130_fd_pr__nfet_01v8 ad=7.875 pd=16.25 as=4.095 ps=8.17 w=7 l=0.18
X428 DRN_LVC1 a_450_404# SRC_BDY_LVC1 SRC_BDY_LVC1 sky130_fd_pr__nfet_01v8 ad=3.535 pd=8.01 as=3.5 ps=15 w=7 l=0.18
X429 SRC_BDY_LVC2 a_2872_5340# DRN_LVC2 SRC_BDY_LVC2 sky130_fd_pr__nfet_01v8 ad=3.5 pd=15 as=3.535 ps=8.01 w=7 l=0.18
X430 SRC_BDY_LVC1 a_450_404# DRN_LVC1 SRC_BDY_LVC1 sky130_fd_pr__nfet_01v8 ad=7.875 pd=16.25 as=4.095 ps=8.17 w=7 l=0.18
X431 SRC_BDY_LVC2 a_2872_5340# DRN_LVC2 SRC_BDY_LVC2 sky130_fd_pr__nfet_01v8 ad=3.5 pd=15 as=3.535 ps=8.01 w=7 l=0.18
X432 SRC_BDY_LVC1 a_450_404# DRN_LVC1 SRC_BDY_LVC1 sky130_fd_pr__nfet_01v8 ad=3.5 pd=15 as=3.535 ps=8.01 w=7 l=0.18
X433 DRN_LVC1 a_450_404# SRC_BDY_LVC1 SRC_BDY_LVC1 sky130_fd_pr__nfet_01v8 ad=4.095 pd=8.17 as=7.875 ps=16.25 w=7 l=0.18
X434 DRN_LVC1 a_450_404# SRC_BDY_LVC1 SRC_BDY_LVC1 sky130_fd_pr__nfet_01v8 ad=4.095 pd=8.17 as=7.875 ps=16.25 w=7 l=0.18
X435 DRN_LVC1 a_414_306# a_450_404# DRN_LVC1 sky130_fd_pr__pfet_01v8 ad=0.98 pd=7.28 as=0.98 ps=7.28 w=7 l=0.18
X436 SRC_BDY_LVC2 a_2872_5340# DRN_LVC2 SRC_BDY_LVC2 sky130_fd_pr__nfet_01v8 ad=3.5 pd=15 as=3.535 ps=8.01 w=7 l=0.18
X437 SRC_BDY_LVC1 a_450_404# DRN_LVC1 SRC_BDY_LVC1 sky130_fd_pr__nfet_01v8 ad=3.5 pd=15 as=3.535 ps=8.01 w=7 l=0.18
X438 DRN_LVC1 a_450_404# SRC_BDY_LVC1 SRC_BDY_LVC1 sky130_fd_pr__nfet_01v8 ad=3.535 pd=8.01 as=3.5 ps=15 w=7 l=0.18
X439 DRN_LVC2 a_2872_5340# SRC_BDY_LVC2 SRC_BDY_LVC2 sky130_fd_pr__nfet_01v8 ad=2.525 pd=6.01 as=2.5 ps=11 w=5 l=0.18
X440 BDY2_B2B SRC_BDY_LVC1 sky130_fd_pr__diode_pd2nw_05v5 perim=3.3e+07 area=2.25e+13
X441 DRN_LVC2 a_2872_5340# SRC_BDY_LVC2 SRC_BDY_LVC2 sky130_fd_pr__nfet_01v8 ad=3.535 pd=8.01 as=3.5 ps=15 w=7 l=0.18
X442 SRC_BDY_LVC1 a_450_404# DRN_LVC1 SRC_BDY_LVC1 sky130_fd_pr__nfet_01v8 ad=7.875 pd=16.25 as=4.095 ps=8.17 w=7 l=0.18
X443 DRN_LVC2 a_2872_5340# SRC_BDY_LVC2 SRC_BDY_LVC2 sky130_fd_pr__nfet_01v8 ad=3.535 pd=8.01 as=3.5 ps=15 w=7 l=0.18
X444 SRC_BDY_LVC2 a_2595_15129# SRC_BDY_LVC2 SRC_BDY_LVC2 sky130_fd_pr__nfet_01v8 ad=1.325 pd=10.53 as=0 ps=0 w=5 l=4
X445 SRC_BDY_LVC2 a_2872_5340# DRN_LVC2 SRC_BDY_LVC2 sky130_fd_pr__nfet_01v8 ad=3.5 pd=15 as=3.535 ps=8.01 w=7 l=0.18
X446 SRC_BDY_LVC2 a_2872_5340# DRN_LVC2 SRC_BDY_LVC2 sky130_fd_pr__nfet_01v8 ad=2.5 pd=11 as=2.525 ps=6.01 w=5 l=0.18
X447 DRN_LVC1 a_450_404# SRC_BDY_LVC1 SRC_BDY_LVC1 sky130_fd_pr__nfet_01v8 ad=4.095 pd=8.17 as=7.875 ps=16.25 w=7 l=0.18
X448 DRN_LVC1 a_450_404# SRC_BDY_LVC1 SRC_BDY_LVC1 sky130_fd_pr__nfet_01v8 ad=2.925 pd=6.17 as=5.625 ps=12.25 w=5 l=0.18
X449 SRC_BDY_LVC2 a_2872_5340# DRN_LVC2 SRC_BDY_LVC2 sky130_fd_pr__nfet_01v8 ad=3.5 pd=15 as=3.535 ps=8.01 w=7 l=0.18
X450 DRN_LVC1 a_450_404# SRC_BDY_LVC1 SRC_BDY_LVC1 sky130_fd_pr__nfet_01v8 ad=4.095 pd=8.17 as=7.875 ps=16.25 w=7 l=0.18
X451 SRC_BDY_LVC1 a_450_404# DRN_LVC1 SRC_BDY_LVC1 sky130_fd_pr__nfet_01v8 ad=3.5 pd=15 as=3.535 ps=8.01 w=7 l=0.18
X452 DRN_LVC2 a_2872_5340# SRC_BDY_LVC2 SRC_BDY_LVC2 sky130_fd_pr__nfet_01v8 ad=3.535 pd=8.01 as=3.5 ps=15 w=7 l=0.18
X453 SRC_BDY_LVC2 a_2872_5340# DRN_LVC2 SRC_BDY_LVC2 sky130_fd_pr__nfet_01v8 ad=3.5 pd=15 as=3.535 ps=8.01 w=7 l=0.18
X454 SRC_BDY_LVC1 a_450_404# DRN_LVC1 SRC_BDY_LVC1 sky130_fd_pr__nfet_01v8 ad=7.875 pd=16.25 as=4.095 ps=8.17 w=7 l=0.18
X455 DRN_LVC1 a_450_404# SRC_BDY_LVC1 SRC_BDY_LVC1 sky130_fd_pr__nfet_01v8 ad=2.925 pd=6.17 as=5.625 ps=12.25 w=5 l=0.18
X456 DRN_LVC2 a_2872_5340# SRC_BDY_LVC2 SRC_BDY_LVC2 sky130_fd_pr__nfet_01v8 ad=3.535 pd=8.01 as=3.5 ps=15 w=7 l=0.18
X457 DRN_LVC1 a_450_404# SRC_BDY_LVC1 SRC_BDY_LVC1 sky130_fd_pr__nfet_01v8 ad=3.535 pd=8.01 as=3.5 ps=15 w=7 l=0.18
X458 DRN_LVC2 a_2872_5340# SRC_BDY_LVC2 SRC_BDY_LVC2 sky130_fd_pr__nfet_01v8 ad=3.535 pd=8.01 as=3.5 ps=15 w=7 l=0.18
X459 SRC_BDY_LVC2 a_2872_5340# DRN_LVC2 SRC_BDY_LVC2 sky130_fd_pr__nfet_01v8 ad=2.5 pd=11 as=2.525 ps=6.01 w=5 l=0.18
X460 SRC_BDY_LVC1 a_450_404# DRN_LVC1 SRC_BDY_LVC1 sky130_fd_pr__nfet_01v8 ad=7.875 pd=16.25 as=4.095 ps=8.17 w=7 l=0.18
X461 SRC_BDY_LVC1 a_450_404# DRN_LVC1 SRC_BDY_LVC1 sky130_fd_pr__nfet_01v8 ad=7.875 pd=16.25 as=4.095 ps=8.17 w=7 l=0.18
X462 DRN_LVC2 a_2595_15129# a_2872_5340# DRN_LVC2 sky130_fd_pr__pfet_01v8 ad=0.98 pd=7.28 as=0.98 ps=7.28 w=7 l=0.18
R1 P_CORE PADISOR sky130_fd_pr__res_generic_m3 w=12.24 l=10m
X463 DRN_LVC2 a_2872_5340# SRC_BDY_LVC2 SRC_BDY_LVC2 sky130_fd_pr__nfet_01v8 ad=2.525 pd=6.01 as=2.5 ps=11 w=5 l=0.18
X464 SRC_BDY_LVC1 a_450_404# DRN_LVC1 SRC_BDY_LVC1 sky130_fd_pr__nfet_01v8 ad=3.5 pd=15 as=3.535 ps=8.01 w=7 l=0.18
X465 DRN_LVC1 a_450_404# SRC_BDY_LVC1 SRC_BDY_LVC1 sky130_fd_pr__nfet_01v8 ad=4.095 pd=8.17 as=7.875 ps=16.25 w=7 l=0.18
.ends

.subckt sky130_ef_io__vccd_lvc_pad DRN_LVC1 DRN_LVC2 SRC_BDY_LVC1 SRC_BDY_LVC2 BDY2_B2B
+ VCCD_PAD VDDA VCCHIB AMUXBUS_B AMUXBUS_A VCCD VDDIO VSSD VSSIO VDDIO_Q VSWITCH VSSA
+ VSSIO_Q
Xsky130_fd_io__top_power_lvc_wpad_0 VSSIO_Q VCCHIB VDDA VDDIO_Q VCCD_PAD SRC_BDY_LVC1
+ SRC_BDY_LVC2 BDY2_B2B DRN_LVC2 DRN_LVC1 VCCD sky130_fd_io__top_power_lvc_wpad_0/PADISOR
+ sky130_fd_io__top_power_lvc_wpad_0/PADISOL BDY2_B2B AMUXBUS_B VSSIO VDDIO VSSD VSWITCH
+ VSSA AMUXBUS_A VCCD sky130_fd_io__top_power_lvc_wpad
.ends

.subckt sky130_fd_io__top_ground_hvc_wpad VCCHIB VDDA VDDIO_Q VSSIO_Q G_PAD PADISOR
+ PADISOL DRN_HVC SRC_BDY_HVC OGC_HVC G_CORE AMUXBUS_B VSSIO VDDIO VSSD VSWITCH VSSA
+ AMUXBUS_A VCCD
Xsky130_fd_io__sio_clamp_pcap_4x5_0 SRC_BDY_HVC a_1268_5934# sky130_fd_io__sio_clamp_pcap_4x5
Xsky130_fd_io__com_busses_esd_0 VCCHIB G_PAD VSSD G_CORE AMUXBUS_A VCCD AMUXBUS_B
+ VDDIO VSSA VSSIO VSWITCH VDDA VSSIO_Q VDDIO_Q sky130_fd_io__com_busses_esd
Xsky130_fd_io__sio_clamp_pcap_4x5_1[0] SRC_BDY_HVC a_1268_5934# sky130_fd_io__sio_clamp_pcap_4x5
Xsky130_fd_io__sio_clamp_pcap_4x5_1[1] SRC_BDY_HVC a_1268_5934# sky130_fd_io__sio_clamp_pcap_4x5
Xsky130_fd_io__sio_clamp_pcap_4x5_1[2] SRC_BDY_HVC a_1268_5934# sky130_fd_io__sio_clamp_pcap_4x5
Xsky130_fd_io__esd_rcclamp_nfetcap_0[0|0] a_1268_5934# SRC_BDY_HVC sky130_fd_io__esd_rcclamp_nfetcap
Xsky130_fd_io__esd_rcclamp_nfetcap_0[1|0] a_1268_5934# SRC_BDY_HVC sky130_fd_io__esd_rcclamp_nfetcap
Xsky130_fd_io__esd_rcclamp_nfetcap_0[2|0] a_1268_5934# SRC_BDY_HVC sky130_fd_io__esd_rcclamp_nfetcap
Xsky130_fd_io__esd_rcclamp_nfetcap_0[0|1] a_1268_5934# SRC_BDY_HVC sky130_fd_io__esd_rcclamp_nfetcap
Xsky130_fd_io__esd_rcclamp_nfetcap_0[1|1] a_1268_5934# SRC_BDY_HVC sky130_fd_io__esd_rcclamp_nfetcap
Xsky130_fd_io__esd_rcclamp_nfetcap_0[2|1] a_1268_5934# SRC_BDY_HVC sky130_fd_io__esd_rcclamp_nfetcap
Xsky130_fd_io__esd_rcclamp_nfetcap_0[0|2] a_1268_5934# SRC_BDY_HVC sky130_fd_io__esd_rcclamp_nfetcap
Xsky130_fd_io__esd_rcclamp_nfetcap_0[1|2] a_1268_5934# SRC_BDY_HVC sky130_fd_io__esd_rcclamp_nfetcap
Xsky130_fd_io__esd_rcclamp_nfetcap_0[2|2] a_1268_5934# SRC_BDY_HVC sky130_fd_io__esd_rcclamp_nfetcap
Xsky130_fd_io__esd_rcclamp_nfetcap_0[0|3] a_1268_5934# SRC_BDY_HVC sky130_fd_io__esd_rcclamp_nfetcap
Xsky130_fd_io__esd_rcclamp_nfetcap_0[1|3] a_1268_5934# SRC_BDY_HVC sky130_fd_io__esd_rcclamp_nfetcap
Xsky130_fd_io__esd_rcclamp_nfetcap_0[2|3] a_1268_5934# SRC_BDY_HVC sky130_fd_io__esd_rcclamp_nfetcap
Xsky130_fd_io__esd_rcclamp_nfetcap_0[0|4] a_1268_5934# SRC_BDY_HVC sky130_fd_io__esd_rcclamp_nfetcap
Xsky130_fd_io__esd_rcclamp_nfetcap_0[1|4] a_1268_5934# SRC_BDY_HVC sky130_fd_io__esd_rcclamp_nfetcap
Xsky130_fd_io__esd_rcclamp_nfetcap_0[2|4] a_1268_5934# SRC_BDY_HVC sky130_fd_io__esd_rcclamp_nfetcap
X0 DRN_HVC a_1368_5960# SRC_BDY_HVC SRC_BDY_HVC sky130_fd_pr__nfet_g5v0d10v5 ad=15.1 pd=21.51 as=13.9 ps=41.39 w=20 l=0.5
X1 DRN_HVC a_1268_5934# a_1368_5960# DRN_HVC sky130_fd_pr__pfet_g5v0d10v5 ad=0.98 pd=7.28 as=0.98 ps=7.28 w=7 l=0.5
X2 SRC_BDY_HVC a_1368_5960# DRN_HVC SRC_BDY_HVC sky130_fd_pr__nfet_g5v0d10v5 ad=6.95 pd=21.39 as=7.55 ps=11.51 w=10 l=0.5
X3 DRN_HVC a_1368_5960# SRC_BDY_HVC SRC_BDY_HVC sky130_fd_pr__nfet_g5v0d10v5 ad=15.1 pd=21.51 as=13.9 ps=41.39 w=20 l=0.5
X4 a_1368_5960# a_1268_5934# DRN_HVC DRN_HVC sky130_fd_pr__pfet_g5v0d10v5 ad=0.98 pd=7.28 as=1.855 ps=14.53 w=7 l=0.5
X5 DRN_HVC a_1368_5960# SRC_BDY_HVC SRC_BDY_HVC sky130_fd_pr__nfet_g5v0d10v5 ad=15.1 pd=21.51 as=13.9 ps=41.39 w=20 l=0.5
X6 DRN_HVC a_1368_5960# SRC_BDY_HVC SRC_BDY_HVC sky130_fd_pr__nfet_g5v0d10v5 ad=15.1 pd=21.51 as=13.9 ps=41.39 w=20 l=0.5
X7 DRN_HVC a_1368_5960# SRC_BDY_HVC SRC_BDY_HVC sky130_fd_pr__nfet_g5v0d10v5 ad=15.1 pd=21.51 as=13.9 ps=41.39 w=20 l=0.5
X8 SRC_BDY_HVC a_1368_5960# DRN_HVC SRC_BDY_HVC sky130_fd_pr__nfet_g5v0d10v5 ad=13.9 pd=41.39 as=15.1 ps=21.51 w=20 l=0.5
X9 SRC_BDY_HVC a_1368_5960# DRN_HVC SRC_BDY_HVC sky130_fd_pr__nfet_g5v0d10v5 ad=13.9 pd=41.39 as=15.1 ps=21.51 w=20 l=0.5
X10 a_1368_5960# a_1268_5934# DRN_HVC DRN_HVC sky130_fd_pr__pfet_g5v0d10v5 ad=0.98 pd=7.28 as=0.98 ps=7.28 w=7 l=0.5
X11 DRN_HVC a_1268_5934# a_1368_5960# DRN_HVC sky130_fd_pr__pfet_g5v0d10v5 ad=0.98 pd=7.28 as=0.98 ps=7.28 w=7 l=0.5
X12 SRC_BDY_HVC a_1368_5960# DRN_HVC SRC_BDY_HVC sky130_fd_pr__nfet_g5v0d10v5 ad=13.9 pd=41.39 as=15.1 ps=21.51 w=20 l=0.5
X13 DRN_HVC a_1368_5960# SRC_BDY_HVC SRC_BDY_HVC sky130_fd_pr__nfet_g5v0d10v5 ad=15.1 pd=21.51 as=13.9 ps=41.39 w=20 l=0.5
X14 a_1368_5960# a_1268_5934# DRN_HVC DRN_HVC sky130_fd_pr__pfet_g5v0d10v5 ad=0.98 pd=7.28 as=0.98 ps=7.28 w=7 l=0.5
X15 DRN_HVC a_1268_5934# a_1368_5960# DRN_HVC sky130_fd_pr__pfet_g5v0d10v5 ad=0.98 pd=7.28 as=0.98 ps=7.28 w=7 l=0.5
X16 DRN_HVC a_1268_5934# a_1368_5960# DRN_HVC sky130_fd_pr__pfet_g5v0d10v5 ad=0.98 pd=7.28 as=0.98 ps=7.28 w=7 l=0.5
X17 DRN_HVC a_1368_5960# SRC_BDY_HVC SRC_BDY_HVC sky130_fd_pr__nfet_g5v0d10v5 ad=7.55 pd=11.51 as=6.95 ps=21.39 w=10 l=0.5
X18 a_1368_5960# a_1268_5934# DRN_HVC DRN_HVC sky130_fd_pr__pfet_g5v0d10v5 ad=0.98 pd=7.28 as=0.98 ps=7.28 w=7 l=0.5
X19 DRN_HVC a_1268_5934# a_1368_5960# DRN_HVC sky130_fd_pr__pfet_g5v0d10v5 ad=0.98 pd=7.28 as=0.98 ps=7.28 w=7 l=0.5
X20 DRN_HVC a_1368_5960# SRC_BDY_HVC SRC_BDY_HVC sky130_fd_pr__nfet_g5v0d10v5 ad=15.1 pd=21.51 as=13.9 ps=41.39 w=20 l=0.5
X21 SRC_BDY_HVC a_1368_5960# DRN_HVC SRC_BDY_HVC sky130_fd_pr__nfet_g5v0d10v5 ad=13.9 pd=41.39 as=15.1 ps=21.51 w=20 l=0.5
X22 DRN_HVC a_1368_5960# SRC_BDY_HVC SRC_BDY_HVC sky130_fd_pr__nfet_g5v0d10v5 ad=7.55 pd=11.51 as=6.95 ps=21.39 w=10 l=0.5
X23 SRC_BDY_HVC a_1368_5960# DRN_HVC SRC_BDY_HVC sky130_fd_pr__nfet_g5v0d10v5 ad=13.9 pd=41.39 as=15.1 ps=21.51 w=20 l=0.5
X24 DRN_HVC a_1368_5960# SRC_BDY_HVC SRC_BDY_HVC sky130_fd_pr__nfet_g5v0d10v5 ad=15.1 pd=21.51 as=13.9 ps=41.39 w=20 l=0.5
X25 SRC_BDY_HVC a_1368_5960# DRN_HVC SRC_BDY_HVC sky130_fd_pr__nfet_g5v0d10v5 ad=6.95 pd=21.39 as=7.55 ps=11.51 w=10 l=0.5
X26 DRN_HVC a_1368_5960# SRC_BDY_HVC SRC_BDY_HVC sky130_fd_pr__nfet_g5v0d10v5 ad=15.1 pd=21.51 as=13.9 ps=41.39 w=20 l=0.5
X27 DRN_HVC a_1368_5960# SRC_BDY_HVC SRC_BDY_HVC sky130_fd_pr__nfet_g5v0d10v5 ad=15.1 pd=21.51 as=13.9 ps=41.39 w=20 l=0.5
X28 a_1368_5960# a_1268_5934# DRN_HVC DRN_HVC sky130_fd_pr__pfet_g5v0d10v5 ad=0.98 pd=7.28 as=0.98 ps=7.28 w=7 l=0.5
X29 DRN_HVC a_1368_5960# SRC_BDY_HVC SRC_BDY_HVC sky130_fd_pr__nfet_g5v0d10v5 ad=7.55 pd=11.51 as=6.95 ps=21.39 w=10 l=0.5
X30 a_1368_5960# a_1268_5934# SRC_BDY_HVC SRC_BDY_HVC sky130_fd_pr__nfet_g5v0d10v5 ad=0.98 pd=7.28 as=0.98 ps=7.28 w=7 l=0.5
X31 DRN_HVC a_1268_5934# a_1368_5960# DRN_HVC sky130_fd_pr__pfet_g5v0d10v5 ad=0.98 pd=7.28 as=0.98 ps=7.28 w=7 l=0.5
X32 SRC_BDY_HVC a_1368_5960# DRN_HVC SRC_BDY_HVC sky130_fd_pr__nfet_g5v0d10v5 ad=6.95 pd=21.39 as=7.55 ps=11.51 w=10 l=0.5
X33 SRC_BDY_HVC a_1368_5960# DRN_HVC SRC_BDY_HVC sky130_fd_pr__nfet_g5v0d10v5 ad=13.9 pd=41.39 as=15.1 ps=21.51 w=20 l=0.5
X34 a_1368_5960# a_1268_5934# DRN_HVC DRN_HVC sky130_fd_pr__pfet_g5v0d10v5 ad=0.98 pd=7.28 as=0.98 ps=7.28 w=7 l=0.5
X35 DRN_HVC a_1268_5934# a_1368_5960# DRN_HVC sky130_fd_pr__pfet_g5v0d10v5 ad=0.98 pd=7.28 as=0.98 ps=7.28 w=7 l=0.5
X36 SRC_BDY_HVC a_1368_5960# DRN_HVC SRC_BDY_HVC sky130_fd_pr__nfet_g5v0d10v5 ad=13.9 pd=41.39 as=15.1 ps=21.51 w=20 l=0.5
X37 a_1368_5960# a_1268_5934# DRN_HVC DRN_HVC sky130_fd_pr__pfet_g5v0d10v5 ad=0.98 pd=7.28 as=0.98 ps=7.28 w=7 l=0.5
X38 DRN_HVC a_1368_5960# SRC_BDY_HVC SRC_BDY_HVC sky130_fd_pr__nfet_g5v0d10v5 ad=15.1 pd=21.51 as=13.9 ps=41.39 w=20 l=0.5
X39 SRC_BDY_HVC a_1368_5960# DRN_HVC SRC_BDY_HVC sky130_fd_pr__nfet_g5v0d10v5 ad=13.9 pd=41.39 as=15.1 ps=21.51 w=20 l=0.5
X40 SRC_BDY_HVC a_1368_5960# DRN_HVC SRC_BDY_HVC sky130_fd_pr__nfet_g5v0d10v5 ad=13.9 pd=41.39 as=15.1 ps=21.51 w=20 l=0.5
X41 a_1368_5960# a_1268_5934# SRC_BDY_HVC SRC_BDY_HVC sky130_fd_pr__nfet_g5v0d10v5 ad=0.98 pd=7.28 as=0.98 ps=7.28 w=7 l=0.5
X42 a_1368_5960# a_1268_5934# DRN_HVC DRN_HVC sky130_fd_pr__pfet_g5v0d10v5 ad=0.98 pd=7.28 as=0.98 ps=7.28 w=7 l=0.5
X43 DRN_HVC a_1268_5934# a_1368_5960# DRN_HVC sky130_fd_pr__pfet_g5v0d10v5 ad=0.98 pd=7.28 as=0.98 ps=7.28 w=7 l=0.5
X44 DRN_HVC a_1368_5960# SRC_BDY_HVC SRC_BDY_HVC sky130_fd_pr__nfet_g5v0d10v5 ad=15.1 pd=21.51 as=13.9 ps=41.39 w=20 l=0.5
X45 SRC_BDY_HVC a_1368_5960# DRN_HVC SRC_BDY_HVC sky130_fd_pr__nfet_g5v0d10v5 ad=13.9 pd=41.39 as=15.1 ps=21.51 w=20 l=0.5
X46 DRN_HVC a_1368_5960# SRC_BDY_HVC SRC_BDY_HVC sky130_fd_pr__nfet_g5v0d10v5 ad=15.1 pd=21.51 as=13.9 ps=41.39 w=20 l=0.5
X47 SRC_BDY_HVC a_1268_5934# a_1368_5960# SRC_BDY_HVC sky130_fd_pr__nfet_g5v0d10v5 ad=0.98 pd=7.28 as=0.98 ps=7.28 w=7 l=0.5
X48 DRN_HVC a_1268_5934# a_1368_5960# DRN_HVC sky130_fd_pr__pfet_g5v0d10v5 ad=0.98 pd=7.28 as=0.98 ps=7.28 w=7 l=0.5
X49 DRN_HVC a_1368_5960# SRC_BDY_HVC SRC_BDY_HVC sky130_fd_pr__nfet_g5v0d10v5 ad=7.55 pd=11.51 as=6.95 ps=21.39 w=10 l=0.5
X50 DRN_HVC a_1368_5960# SRC_BDY_HVC SRC_BDY_HVC sky130_fd_pr__nfet_g5v0d10v5 ad=15.1 pd=21.51 as=13.9 ps=41.39 w=20 l=0.5
X51 DRN_HVC a_1368_5960# SRC_BDY_HVC SRC_BDY_HVC sky130_fd_pr__nfet_g5v0d10v5 ad=15.1 pd=21.51 as=13.9 ps=41.39 w=20 l=0.5
X52 a_1368_5960# a_1268_5934# SRC_BDY_HVC SRC_BDY_HVC sky130_fd_pr__nfet_g5v0d10v5 ad=0.98 pd=7.28 as=0.98 ps=7.28 w=7 l=0.5
X53 a_1368_5960# a_1268_5934# DRN_HVC DRN_HVC sky130_fd_pr__pfet_g5v0d10v5 ad=0.98 pd=7.28 as=0.98 ps=7.28 w=7 l=0.5
X54 DRN_HVC a_1368_5960# SRC_BDY_HVC SRC_BDY_HVC sky130_fd_pr__nfet_g5v0d10v5 ad=15.1 pd=21.51 as=13.9 ps=41.39 w=20 l=0.5
X55 SRC_BDY_HVC a_1268_5934# a_1368_5960# SRC_BDY_HVC sky130_fd_pr__nfet_g5v0d10v5 ad=0.98 pd=7.28 as=0.98 ps=7.28 w=7 l=0.5
X56 SRC_BDY_HVC a_1368_5960# DRN_HVC SRC_BDY_HVC sky130_fd_pr__nfet_g5v0d10v5 ad=13.9 pd=41.39 as=15.1 ps=21.51 w=20 l=0.5
X57 SRC_BDY_HVC a_1368_5960# DRN_HVC SRC_BDY_HVC sky130_fd_pr__nfet_g5v0d10v5 ad=13.9 pd=41.39 as=15.1 ps=21.51 w=20 l=0.5
X58 SRC_BDY_HVC a_1368_5960# DRN_HVC SRC_BDY_HVC sky130_fd_pr__nfet_g5v0d10v5 ad=13.9 pd=41.39 as=15.1 ps=21.51 w=20 l=0.5
X59 DRN_HVC a_1368_5960# SRC_BDY_HVC SRC_BDY_HVC sky130_fd_pr__nfet_g5v0d10v5 ad=15.1 pd=21.51 as=13.9 ps=41.39 w=20 l=0.5
X60 SRC_BDY_HVC a_1368_5960# DRN_HVC SRC_BDY_HVC sky130_fd_pr__nfet_g5v0d10v5 ad=13.9 pd=41.39 as=15.1 ps=21.51 w=20 l=0.5
X61 DRN_HVC a_1368_5960# SRC_BDY_HVC SRC_BDY_HVC sky130_fd_pr__nfet_g5v0d10v5 ad=15.1 pd=21.51 as=13.9 ps=41.39 w=20 l=0.5
X62 SRC_BDY_HVC a_1368_5960# DRN_HVC SRC_BDY_HVC sky130_fd_pr__nfet_g5v0d10v5 ad=6.95 pd=21.39 as=7.55 ps=11.51 w=10 l=0.5
X63 DRN_HVC a_1368_5960# SRC_BDY_HVC SRC_BDY_HVC sky130_fd_pr__nfet_g5v0d10v5 ad=15.1 pd=21.51 as=13.9 ps=41.39 w=20 l=0.5
R0 G_CORE PADISOL sky130_fd_pr__res_generic_m3 w=11.825 l=10m
X64 SRC_BDY_HVC a_1268_5934# SRC_BDY_HVC SRC_BDY_HVC sky130_fd_pr__nfet_g5v0d10v5 ad=1.325 pd=10.53 as=0 ps=0 w=5 l=4
X65 DRN_HVC a_1368_5960# SRC_BDY_HVC SRC_BDY_HVC sky130_fd_pr__nfet_g5v0d10v5 ad=7.55 pd=11.51 as=6.95 ps=21.39 w=10 l=0.5
X66 DRN_HVC a_1368_5960# SRC_BDY_HVC SRC_BDY_HVC sky130_fd_pr__nfet_g5v0d10v5 ad=15.1 pd=21.51 as=13.9 ps=41.39 w=20 l=0.5
X67 DRN_HVC a_1368_5960# SRC_BDY_HVC SRC_BDY_HVC sky130_fd_pr__nfet_g5v0d10v5 ad=15.1 pd=21.51 as=13.9 ps=41.39 w=20 l=0.5
X68 a_1368_5960# a_1268_5934# DRN_HVC DRN_HVC sky130_fd_pr__pfet_g5v0d10v5 ad=0.98 pd=7.28 as=0.98 ps=7.28 w=7 l=0.5
X69 SRC_BDY_HVC a_1368_5960# DRN_HVC SRC_BDY_HVC sky130_fd_pr__nfet_g5v0d10v5 ad=13.9 pd=41.39 as=15.1 ps=21.51 w=20 l=0.5
X70 SRC_BDY_HVC a_1368_5960# DRN_HVC SRC_BDY_HVC sky130_fd_pr__nfet_g5v0d10v5 ad=13.9 pd=41.39 as=15.1 ps=21.51 w=20 l=0.5
X71 SRC_BDY_HVC a_1368_5960# DRN_HVC SRC_BDY_HVC sky130_fd_pr__nfet_g5v0d10v5 ad=13.9 pd=41.39 as=15.1 ps=21.51 w=20 l=0.5
X72 SRC_BDY_HVC a_1368_5960# DRN_HVC SRC_BDY_HVC sky130_fd_pr__nfet_g5v0d10v5 ad=6.95 pd=21.39 as=7.55 ps=11.51 w=10 l=0.5
X73 SRC_BDY_HVC a_1368_5960# DRN_HVC SRC_BDY_HVC sky130_fd_pr__nfet_g5v0d10v5 ad=13.9 pd=41.39 as=15.1 ps=21.51 w=20 l=0.5
X74 SRC_BDY_HVC a_1368_5960# DRN_HVC SRC_BDY_HVC sky130_fd_pr__nfet_g5v0d10v5 ad=13.9 pd=41.39 as=15.1 ps=21.51 w=20 l=0.5
X75 SRC_BDY_HVC a_1368_5960# DRN_HVC SRC_BDY_HVC sky130_fd_pr__nfet_g5v0d10v5 ad=13.9 pd=41.39 as=15.1 ps=21.51 w=20 l=0.5
X76 SRC_BDY_HVC a_1368_5960# DRN_HVC SRC_BDY_HVC sky130_fd_pr__nfet_g5v0d10v5 ad=13.9 pd=41.39 as=15.1 ps=21.51 w=20 l=0.5
X77 DRN_HVC a_1368_5960# SRC_BDY_HVC SRC_BDY_HVC sky130_fd_pr__nfet_g5v0d10v5 ad=15.1 pd=21.51 as=13.9 ps=41.39 w=20 l=0.5
X78 SRC_BDY_HVC a_1368_5960# DRN_HVC SRC_BDY_HVC sky130_fd_pr__nfet_g5v0d10v5 ad=13.9 pd=41.39 as=15.1 ps=21.51 w=20 l=0.5
X79 a_1368_5960# a_1268_5934# DRN_HVC DRN_HVC sky130_fd_pr__pfet_g5v0d10v5 ad=0.98 pd=7.28 as=0.98 ps=7.28 w=7 l=0.5
X80 DRN_HVC a_1268_5934# a_1368_5960# DRN_HVC sky130_fd_pr__pfet_g5v0d10v5 ad=0.98 pd=7.28 as=0.98 ps=7.28 w=7 l=0.5
X81 SRC_BDY_HVC a_1368_5960# DRN_HVC SRC_BDY_HVC sky130_fd_pr__nfet_g5v0d10v5 ad=13.9 pd=41.39 as=15.1 ps=21.51 w=20 l=0.5
X82 SRC_BDY_HVC a_1368_5960# DRN_HVC SRC_BDY_HVC sky130_fd_pr__nfet_g5v0d10v5 ad=13.9 pd=41.39 as=15.1 ps=21.51 w=20 l=0.5
X83 DRN_HVC a_1368_5960# SRC_BDY_HVC SRC_BDY_HVC sky130_fd_pr__nfet_g5v0d10v5 ad=15.1 pd=21.51 as=13.9 ps=41.39 w=20 l=0.5
X84 SRC_BDY_HVC a_1368_5960# DRN_HVC SRC_BDY_HVC sky130_fd_pr__nfet_g5v0d10v5 ad=13.9 pd=41.39 as=15.1 ps=21.51 w=20 l=0.5
X85 DRN_HVC a_1368_5960# SRC_BDY_HVC SRC_BDY_HVC sky130_fd_pr__nfet_g5v0d10v5 ad=15.1 pd=21.51 as=13.9 ps=41.39 w=20 l=0.5
X86 DRN_HVC a_1368_5960# SRC_BDY_HVC SRC_BDY_HVC sky130_fd_pr__nfet_g5v0d10v5 ad=15.1 pd=21.51 as=13.9 ps=41.39 w=20 l=0.5
X87 SRC_BDY_HVC a_1368_5960# DRN_HVC SRC_BDY_HVC sky130_fd_pr__nfet_g5v0d10v5 ad=6.95 pd=21.39 as=7.55 ps=11.51 w=10 l=0.5
X88 DRN_HVC a_1368_5960# SRC_BDY_HVC SRC_BDY_HVC sky130_fd_pr__nfet_g5v0d10v5 ad=15.1 pd=21.51 as=13.9 ps=41.39 w=20 l=0.5
X89 DRN_HVC a_1368_5960# SRC_BDY_HVC SRC_BDY_HVC sky130_fd_pr__nfet_g5v0d10v5 ad=15.1 pd=21.51 as=13.9 ps=41.39 w=20 l=0.5
X90 SRC_BDY_HVC a_1368_5960# DRN_HVC SRC_BDY_HVC sky130_fd_pr__nfet_g5v0d10v5 ad=13.9 pd=41.39 as=15.1 ps=21.51 w=20 l=0.5
X91 DRN_HVC a_1368_5960# SRC_BDY_HVC SRC_BDY_HVC sky130_fd_pr__nfet_g5v0d10v5 ad=15.1 pd=21.51 as=13.9 ps=41.39 w=20 l=0.5
X92 SRC_BDY_HVC a_1268_5934# a_1368_5960# SRC_BDY_HVC sky130_fd_pr__nfet_g5v0d10v5 ad=0.98 pd=7.28 as=0.98 ps=7.28 w=7 l=0.5
X93 a_1368_5960# a_1268_5934# DRN_HVC DRN_HVC sky130_fd_pr__pfet_g5v0d10v5 ad=0.98 pd=7.28 as=0.98 ps=7.28 w=7 l=0.5
X94 DRN_HVC a_1368_5960# SRC_BDY_HVC SRC_BDY_HVC sky130_fd_pr__nfet_g5v0d10v5 ad=15.1 pd=21.51 as=13.9 ps=41.39 w=20 l=0.5
X95 DRN_HVC a_1268_5934# a_1368_5960# DRN_HVC sky130_fd_pr__pfet_g5v0d10v5 ad=0.98 pd=7.28 as=0.98 ps=7.28 w=7 l=0.5
X96 DRN_HVC a_1368_5960# SRC_BDY_HVC SRC_BDY_HVC sky130_fd_pr__nfet_g5v0d10v5 ad=15.1 pd=21.51 as=13.9 ps=41.39 w=20 l=0.5
X97 DRN_HVC a_1368_5960# SRC_BDY_HVC SRC_BDY_HVC sky130_fd_pr__nfet_g5v0d10v5 ad=15.1 pd=21.51 as=13.9 ps=41.39 w=20 l=0.5
X98 DRN_HVC a_1368_5960# SRC_BDY_HVC SRC_BDY_HVC sky130_fd_pr__nfet_g5v0d10v5 ad=15.1 pd=21.51 as=13.9 ps=41.39 w=20 l=0.5
X99 DRN_HVC a_1368_5960# SRC_BDY_HVC SRC_BDY_HVC sky130_fd_pr__nfet_g5v0d10v5 ad=7.55 pd=11.51 as=6.95 ps=21.39 w=10 l=0.5
X100 SRC_BDY_HVC a_1368_5960# DRN_HVC SRC_BDY_HVC sky130_fd_pr__nfet_g5v0d10v5 ad=13.9 pd=41.39 as=15.1 ps=21.51 w=20 l=0.5
R1 G_CORE PADISOR sky130_fd_pr__res_generic_m3 w=11.825 l=10m
X101 SRC_BDY_HVC a_1368_5960# DRN_HVC SRC_BDY_HVC sky130_fd_pr__nfet_g5v0d10v5 ad=13.9 pd=41.39 as=15.1 ps=21.51 w=20 l=0.5
X102 a_1368_5960# a_1268_5934# DRN_HVC DRN_HVC sky130_fd_pr__pfet_g5v0d10v5 ad=0.98 pd=7.28 as=0.98 ps=7.28 w=7 l=0.5
X103 SRC_BDY_HVC a_1368_5960# DRN_HVC SRC_BDY_HVC sky130_fd_pr__nfet_g5v0d10v5 ad=13.9 pd=41.39 as=15.1 ps=21.51 w=20 l=0.5
X104 DRN_HVC a_1368_5960# SRC_BDY_HVC SRC_BDY_HVC sky130_fd_pr__nfet_g5v0d10v5 ad=15.1 pd=21.51 as=13.9 ps=41.39 w=20 l=0.5
X105 SRC_BDY_HVC a_1268_5934# a_1368_5960# SRC_BDY_HVC sky130_fd_pr__nfet_g5v0d10v5 ad=0.98 pd=7.28 as=0.98 ps=7.28 w=7 l=0.5
X106 DRN_HVC a_1268_5934# a_1368_5960# DRN_HVC sky130_fd_pr__pfet_g5v0d10v5 ad=0.98 pd=7.28 as=0.98 ps=7.28 w=7 l=0.5
X107 DRN_HVC a_1368_5960# SRC_BDY_HVC SRC_BDY_HVC sky130_fd_pr__nfet_g5v0d10v5 ad=15.1 pd=21.51 as=13.9 ps=41.39 w=20 l=0.5
X108 SRC_BDY_HVC a_1368_5960# DRN_HVC SRC_BDY_HVC sky130_fd_pr__nfet_g5v0d10v5 ad=13.9 pd=41.39 as=15.1 ps=21.51 w=20 l=0.5
X109 a_1368_5960# a_1268_5934# SRC_BDY_HVC SRC_BDY_HVC sky130_fd_pr__nfet_g5v0d10v5 ad=0.98 pd=7.28 as=0.98 ps=7.28 w=7 l=0.5
X110 a_1368_5960# a_1268_5934# DRN_HVC DRN_HVC sky130_fd_pr__pfet_g5v0d10v5 ad=0.98 pd=7.28 as=0.98 ps=7.28 w=7 l=0.5
X111 DRN_HVC a_1368_5960# SRC_BDY_HVC SRC_BDY_HVC sky130_fd_pr__nfet_g5v0d10v5 ad=7.55 pd=11.51 as=6.95 ps=21.39 w=10 l=0.5
X112 SRC_BDY_HVC a_1368_5960# DRN_HVC SRC_BDY_HVC sky130_fd_pr__nfet_g5v0d10v5 ad=13.9 pd=41.39 as=15.1 ps=21.51 w=20 l=0.5
X113 a_1368_5960# a_1268_5934# DRN_HVC DRN_HVC sky130_fd_pr__pfet_g5v0d10v5 ad=0.98 pd=7.28 as=0.98 ps=7.28 w=7 l=0.5
X114 SRC_BDY_HVC a_1368_5960# DRN_HVC SRC_BDY_HVC sky130_fd_pr__nfet_g5v0d10v5 ad=13.9 pd=41.39 as=15.1 ps=21.51 w=20 l=0.5
X115 SRC_BDY_HVC a_1268_5934# a_1368_5960# SRC_BDY_HVC sky130_fd_pr__nfet_g5v0d10v5 ad=0.98 pd=7.28 as=0.98 ps=7.28 w=7 l=0.5
X116 DRN_HVC a_1268_5934# a_1368_5960# DRN_HVC sky130_fd_pr__pfet_g5v0d10v5 ad=0.98 pd=7.28 as=0.98 ps=7.28 w=7 l=0.5
X117 DRN_HVC a_1368_5960# SRC_BDY_HVC SRC_BDY_HVC sky130_fd_pr__nfet_g5v0d10v5 ad=15.1 pd=21.51 as=13.9 ps=41.39 w=20 l=0.5
X118 a_1368_5960# a_1268_5934# DRN_HVC DRN_HVC sky130_fd_pr__pfet_g5v0d10v5 ad=0.98 pd=7.28 as=0.98 ps=7.28 w=7 l=0.5
X119 DRN_HVC a_1368_5960# SRC_BDY_HVC SRC_BDY_HVC sky130_fd_pr__nfet_g5v0d10v5 ad=15.1 pd=21.51 as=13.9 ps=41.39 w=20 l=0.5
X120 DRN_HVC a_1368_5960# SRC_BDY_HVC SRC_BDY_HVC sky130_fd_pr__nfet_g5v0d10v5 ad=15.1 pd=21.51 as=13.9 ps=41.39 w=20 l=0.5
X121 SRC_BDY_HVC a_1368_5960# DRN_HVC SRC_BDY_HVC sky130_fd_pr__nfet_g5v0d10v5 ad=6.95 pd=21.39 as=7.55 ps=11.51 w=10 l=0.5
X122 SRC_BDY_HVC a_1368_5960# DRN_HVC SRC_BDY_HVC sky130_fd_pr__nfet_g5v0d10v5 ad=6.95 pd=21.39 as=7.55 ps=11.51 w=10 l=0.5
X123 SRC_BDY_HVC a_1368_5960# DRN_HVC SRC_BDY_HVC sky130_fd_pr__nfet_g5v0d10v5 ad=13.9 pd=41.39 as=15.1 ps=21.51 w=20 l=0.5
X124 DRN_HVC a_1268_5934# a_1368_5960# DRN_HVC sky130_fd_pr__pfet_g5v0d10v5 ad=0.98 pd=7.28 as=0.98 ps=7.28 w=7 l=0.5
X125 DRN_HVC a_1368_5960# SRC_BDY_HVC SRC_BDY_HVC sky130_fd_pr__nfet_g5v0d10v5 ad=15.1 pd=21.51 as=13.9 ps=41.39 w=20 l=0.5
X126 DRN_HVC a_1368_5960# SRC_BDY_HVC SRC_BDY_HVC sky130_fd_pr__nfet_g5v0d10v5 ad=15.1 pd=21.51 as=13.9 ps=41.39 w=20 l=0.5
X127 SRC_BDY_HVC a_1368_5960# DRN_HVC SRC_BDY_HVC sky130_fd_pr__nfet_g5v0d10v5 ad=13.9 pd=41.39 as=15.1 ps=21.51 w=20 l=0.5
X128 a_1368_5960# a_1268_5934# DRN_HVC DRN_HVC sky130_fd_pr__pfet_g5v0d10v5 ad=0.98 pd=7.28 as=0.98 ps=7.28 w=7 l=0.5
X129 DRN_HVC a_1368_5960# SRC_BDY_HVC SRC_BDY_HVC sky130_fd_pr__nfet_g5v0d10v5 ad=15.1 pd=21.51 as=13.9 ps=41.39 w=20 l=0.5
X130 DRN_HVC a_1268_5934# a_1368_5960# DRN_HVC sky130_fd_pr__pfet_g5v0d10v5 ad=0.98 pd=7.28 as=0.98 ps=7.28 w=7 l=0.5
X131 DRN_HVC a_1268_5934# a_1368_5960# DRN_HVC sky130_fd_pr__pfet_g5v0d10v5 ad=0.98 pd=7.28 as=0.98 ps=7.28 w=7 l=0.5
X132 a_1368_5960# a_1268_5934# DRN_HVC DRN_HVC sky130_fd_pr__pfet_g5v0d10v5 ad=0.98 pd=7.28 as=0.98 ps=7.28 w=7 l=0.5
X133 DRN_HVC a_1268_5934# a_1368_5960# DRN_HVC sky130_fd_pr__pfet_g5v0d10v5 ad=0.98 pd=7.28 as=0.98 ps=7.28 w=7 l=0.5
X134 a_1368_5960# a_1268_5934# DRN_HVC DRN_HVC sky130_fd_pr__pfet_g5v0d10v5 ad=0.98 pd=7.28 as=0.98 ps=7.28 w=7 l=0.5
X135 SRC_BDY_HVC a_1368_5960# DRN_HVC SRC_BDY_HVC sky130_fd_pr__nfet_g5v0d10v5 ad=13.9 pd=41.39 as=15.1 ps=21.51 w=20 l=0.5
X136 DRN_HVC a_1268_5934# a_1368_5960# DRN_HVC sky130_fd_pr__pfet_g5v0d10v5 ad=0.98 pd=7.28 as=0.98 ps=7.28 w=7 l=0.5
X137 SRC_BDY_HVC a_1368_5960# DRN_HVC SRC_BDY_HVC sky130_fd_pr__nfet_g5v0d10v5 ad=13.9 pd=41.39 as=15.1 ps=21.51 w=20 l=0.5
X138 DRN_HVC a_1268_5934# a_1368_5960# DRN_HVC sky130_fd_pr__pfet_g5v0d10v5 ad=0.98 pd=7.28 as=0.98 ps=7.28 w=7 l=0.5
X139 DRN_HVC a_1368_5960# SRC_BDY_HVC SRC_BDY_HVC sky130_fd_pr__nfet_g5v0d10v5 ad=15.1 pd=21.51 as=13.9 ps=41.39 w=20 l=0.5
X140 a_1368_5960# a_1268_5934# DRN_HVC DRN_HVC sky130_fd_pr__pfet_g5v0d10v5 ad=0.98 pd=7.28 as=0.98 ps=7.28 w=7 l=0.5
X141 DRN_HVC a_1368_5960# SRC_BDY_HVC SRC_BDY_HVC sky130_fd_pr__nfet_g5v0d10v5 ad=7.55 pd=11.51 as=6.95 ps=21.39 w=10 l=0.5
X142 DRN_HVC a_214_8638# sky130_fd_pr__res_generic_po w=0.33 l=700
X143 SRC_BDY_HVC a_1368_5960# DRN_HVC SRC_BDY_HVC sky130_fd_pr__nfet_g5v0d10v5 ad=13.9 pd=41.39 as=15.1 ps=21.51 w=20 l=0.5
X144 DRN_HVC a_1368_5960# SRC_BDY_HVC SRC_BDY_HVC sky130_fd_pr__nfet_g5v0d10v5 ad=15.1 pd=21.51 as=13.9 ps=41.39 w=20 l=0.5
X145 DRN_HVC a_1268_5934# a_1368_5960# DRN_HVC sky130_fd_pr__pfet_g5v0d10v5 ad=1.855 pd=14.53 as=0.98 ps=7.28 w=7 l=0.5
X146 DRN_HVC a_1368_5960# SRC_BDY_HVC SRC_BDY_HVC sky130_fd_pr__nfet_g5v0d10v5 ad=15.1 pd=21.51 as=13.9 ps=41.39 w=20 l=0.5
X147 a_1368_5960# a_1268_5934# SRC_BDY_HVC SRC_BDY_HVC sky130_fd_pr__nfet_g5v0d10v5 ad=0.98 pd=7.28 as=0.98 ps=7.28 w=7 l=0.5
X148 SRC_BDY_HVC a_1268_5934# a_1368_5960# SRC_BDY_HVC sky130_fd_pr__nfet_g5v0d10v5 ad=0.98 pd=7.28 as=0.98 ps=7.28 w=7 l=0.5
X149 a_1368_5960# a_1268_5934# DRN_HVC DRN_HVC sky130_fd_pr__pfet_g5v0d10v5 ad=0.98 pd=7.28 as=0.98 ps=7.28 w=7 l=0.5
X150 DRN_HVC a_1268_5934# a_1368_5960# DRN_HVC sky130_fd_pr__pfet_g5v0d10v5 ad=0.98 pd=7.28 as=0.98 ps=7.28 w=7 l=0.5
X151 a_1368_5960# a_1268_5934# SRC_BDY_HVC SRC_BDY_HVC sky130_fd_pr__nfet_g5v0d10v5 ad=0.98 pd=7.28 as=1.855 ps=14.53 w=7 l=0.5
X152 a_1368_5960# a_1268_5934# DRN_HVC DRN_HVC sky130_fd_pr__pfet_g5v0d10v5 ad=0.98 pd=7.28 as=0.98 ps=7.28 w=7 l=0.5
X153 SRC_BDY_HVC a_1368_5960# DRN_HVC SRC_BDY_HVC sky130_fd_pr__nfet_g5v0d10v5 ad=13.9 pd=41.39 as=15.1 ps=21.51 w=20 l=0.5
X154 a_1368_5960# a_1268_5934# SRC_BDY_HVC SRC_BDY_HVC sky130_fd_pr__nfet_g5v0d10v5 ad=0.98 pd=7.28 as=0.98 ps=7.28 w=7 l=0.5
X155 a_1368_5960# a_1268_5934# DRN_HVC DRN_HVC sky130_fd_pr__pfet_g5v0d10v5 ad=0.98 pd=7.28 as=0.98 ps=7.28 w=7 l=0.5
X156 SRC_BDY_HVC a_1368_5960# DRN_HVC SRC_BDY_HVC sky130_fd_pr__nfet_g5v0d10v5 ad=13.9 pd=41.39 as=15.1 ps=21.51 w=20 l=0.5
X157 DRN_HVC a_1268_5934# a_1368_5960# DRN_HVC sky130_fd_pr__pfet_g5v0d10v5 ad=0.98 pd=7.28 as=0.98 ps=7.28 w=7 l=0.5
X158 SRC_BDY_HVC a_1368_5960# DRN_HVC SRC_BDY_HVC sky130_fd_pr__nfet_g5v0d10v5 ad=13.9 pd=41.39 as=15.1 ps=21.51 w=20 l=0.5
X159 DRN_HVC a_1368_5960# SRC_BDY_HVC SRC_BDY_HVC sky130_fd_pr__nfet_g5v0d10v5 ad=15.1 pd=21.51 as=13.9 ps=41.39 w=20 l=0.5
X160 SRC_BDY_HVC a_1368_5960# DRN_HVC SRC_BDY_HVC sky130_fd_pr__nfet_g5v0d10v5 ad=13.9 pd=41.39 as=15.1 ps=21.51 w=20 l=0.5
X161 DRN_HVC a_1368_5960# SRC_BDY_HVC SRC_BDY_HVC sky130_fd_pr__nfet_g5v0d10v5 ad=15.1 pd=21.51 as=13.9 ps=41.39 w=20 l=0.5
X162 SRC_BDY_HVC a_1368_5960# DRN_HVC SRC_BDY_HVC sky130_fd_pr__nfet_g5v0d10v5 ad=13.9 pd=41.39 as=15.1 ps=21.51 w=20 l=0.5
X163 SRC_BDY_HVC a_1368_5960# DRN_HVC SRC_BDY_HVC sky130_fd_pr__nfet_g5v0d10v5 ad=13.9 pd=41.39 as=15.1 ps=21.51 w=20 l=0.5
X164 DRN_HVC a_1268_5934# a_1368_5960# DRN_HVC sky130_fd_pr__pfet_g5v0d10v5 ad=0.98 pd=7.28 as=0.98 ps=7.28 w=7 l=0.5
X165 SRC_BDY_HVC a_1368_5960# DRN_HVC SRC_BDY_HVC sky130_fd_pr__nfet_g5v0d10v5 ad=13.9 pd=41.39 as=15.1 ps=21.51 w=20 l=0.5
X166 SRC_BDY_HVC a_1368_5960# DRN_HVC SRC_BDY_HVC sky130_fd_pr__nfet_g5v0d10v5 ad=13.9 pd=41.39 as=15.1 ps=21.51 w=20 l=0.5
X167 a_1672_8638# a_214_8638# sky130_fd_pr__res_generic_po w=0.33 l=1.55k
X168 DRN_HVC a_1368_5960# SRC_BDY_HVC SRC_BDY_HVC sky130_fd_pr__nfet_g5v0d10v5 ad=7.55 pd=11.51 as=6.95 ps=21.39 w=10 l=0.5
X169 a_1268_5934# a_1672_8638# sky130_fd_pr__res_generic_po w=0.33 l=470
X170 DRN_HVC a_1368_5960# SRC_BDY_HVC SRC_BDY_HVC sky130_fd_pr__nfet_g5v0d10v5 ad=15.1 pd=21.51 as=13.9 ps=41.39 w=20 l=0.5
X171 SRC_BDY_HVC a_1368_5960# DRN_HVC SRC_BDY_HVC sky130_fd_pr__nfet_g5v0d10v5 ad=13.9 pd=41.39 as=15.1 ps=21.51 w=20 l=0.5
X172 DRN_HVC a_1368_5960# SRC_BDY_HVC SRC_BDY_HVC sky130_fd_pr__nfet_g5v0d10v5 ad=15.1 pd=21.51 as=13.9 ps=41.39 w=20 l=0.5
X173 SRC_BDY_HVC a_1368_5960# DRN_HVC SRC_BDY_HVC sky130_fd_pr__nfet_g5v0d10v5 ad=13.9 pd=41.39 as=15.1 ps=21.51 w=20 l=0.5
X174 SRC_BDY_HVC a_1368_5960# DRN_HVC SRC_BDY_HVC sky130_fd_pr__nfet_g5v0d10v5 ad=6.95 pd=21.39 as=7.55 ps=11.51 w=10 l=0.5
X175 DRN_HVC a_1368_5960# SRC_BDY_HVC SRC_BDY_HVC sky130_fd_pr__nfet_g5v0d10v5 ad=15.1 pd=21.51 as=13.9 ps=41.39 w=20 l=0.5
X176 DRN_HVC a_1368_5960# SRC_BDY_HVC SRC_BDY_HVC sky130_fd_pr__nfet_g5v0d10v5 ad=15.1 pd=21.51 as=13.9 ps=41.39 w=20 l=0.5
X177 DRN_HVC a_1368_5960# SRC_BDY_HVC SRC_BDY_HVC sky130_fd_pr__nfet_g5v0d10v5 ad=15.1 pd=21.51 as=13.9 ps=41.39 w=20 l=0.5
X178 SRC_BDY_HVC a_1368_5960# DRN_HVC SRC_BDY_HVC sky130_fd_pr__nfet_g5v0d10v5 ad=13.9 pd=41.39 as=15.1 ps=21.51 w=20 l=0.5
X179 DRN_HVC a_1368_5960# SRC_BDY_HVC SRC_BDY_HVC sky130_fd_pr__nfet_g5v0d10v5 ad=15.1 pd=21.51 as=13.9 ps=41.39 w=20 l=0.5
X180 DRN_HVC a_1368_5960# SRC_BDY_HVC SRC_BDY_HVC sky130_fd_pr__nfet_g5v0d10v5 ad=15.1 pd=21.51 as=13.9 ps=41.39 w=20 l=0.5
X181 DRN_HVC a_1368_5960# SRC_BDY_HVC SRC_BDY_HVC sky130_fd_pr__nfet_g5v0d10v5 ad=15.1 pd=21.51 as=13.9 ps=41.39 w=20 l=0.5
X182 SRC_BDY_HVC a_1368_5960# DRN_HVC SRC_BDY_HVC sky130_fd_pr__nfet_g5v0d10v5 ad=13.9 pd=41.39 as=15.1 ps=21.51 w=20 l=0.5
X183 DRN_HVC a_1368_5960# SRC_BDY_HVC SRC_BDY_HVC sky130_fd_pr__nfet_g5v0d10v5 ad=7.55 pd=11.51 as=6.95 ps=21.39 w=10 l=0.5
X184 DRN_HVC a_1368_5960# SRC_BDY_HVC SRC_BDY_HVC sky130_fd_pr__nfet_g5v0d10v5 ad=15.1 pd=21.51 as=13.9 ps=41.39 w=20 l=0.5
X185 DRN_HVC a_1368_5960# SRC_BDY_HVC SRC_BDY_HVC sky130_fd_pr__nfet_g5v0d10v5 ad=15.1 pd=21.51 as=13.9 ps=41.39 w=20 l=0.5
X186 DRN_HVC a_1268_5934# a_1368_5960# DRN_HVC sky130_fd_pr__pfet_g5v0d10v5 ad=0.98 pd=7.28 as=0.98 ps=7.28 w=7 l=0.5
X187 DRN_HVC a_1368_5960# SRC_BDY_HVC SRC_BDY_HVC sky130_fd_pr__nfet_g5v0d10v5 ad=15.1 pd=21.51 as=13.9 ps=41.39 w=20 l=0.5
X188 a_1368_5960# a_1268_5934# DRN_HVC DRN_HVC sky130_fd_pr__pfet_g5v0d10v5 ad=0.98 pd=7.28 as=0.98 ps=7.28 w=7 l=0.5
X189 SRC_BDY_HVC a_1368_5960# DRN_HVC SRC_BDY_HVC sky130_fd_pr__nfet_g5v0d10v5 ad=13.9 pd=41.39 as=15.1 ps=21.51 w=20 l=0.5
X190 SRC_BDY_HVC a_1368_5960# DRN_HVC SRC_BDY_HVC sky130_fd_pr__nfet_g5v0d10v5 ad=13.9 pd=41.39 as=15.1 ps=21.51 w=20 l=0.5
X191 DRN_HVC a_1368_5960# SRC_BDY_HVC SRC_BDY_HVC sky130_fd_pr__nfet_g5v0d10v5 ad=15.1 pd=21.51 as=13.9 ps=41.39 w=20 l=0.5
X192 SRC_BDY_HVC a_1368_5960# DRN_HVC SRC_BDY_HVC sky130_fd_pr__nfet_g5v0d10v5 ad=6.95 pd=21.39 as=7.55 ps=11.51 w=10 l=0.5
X193 SRC_BDY_HVC a_1368_5960# DRN_HVC SRC_BDY_HVC sky130_fd_pr__nfet_g5v0d10v5 ad=13.9 pd=41.39 as=15.1 ps=21.51 w=20 l=0.5
X194 SRC_BDY_HVC a_1368_5960# DRN_HVC SRC_BDY_HVC sky130_fd_pr__nfet_g5v0d10v5 ad=13.9 pd=41.39 as=15.1 ps=21.51 w=20 l=0.5
X195 DRN_HVC a_1368_5960# SRC_BDY_HVC SRC_BDY_HVC sky130_fd_pr__nfet_g5v0d10v5 ad=15.1 pd=21.51 as=13.9 ps=41.39 w=20 l=0.5
X196 SRC_BDY_HVC a_1368_5960# DRN_HVC SRC_BDY_HVC sky130_fd_pr__nfet_g5v0d10v5 ad=13.9 pd=41.39 as=15.1 ps=21.51 w=20 l=0.5
X197 SRC_BDY_HVC a_1368_5960# DRN_HVC SRC_BDY_HVC sky130_fd_pr__nfet_g5v0d10v5 ad=13.9 pd=41.39 as=15.1 ps=21.51 w=20 l=0.5
X198 DRN_HVC a_1368_5960# SRC_BDY_HVC SRC_BDY_HVC sky130_fd_pr__nfet_g5v0d10v5 ad=15.1 pd=21.51 as=13.9 ps=41.39 w=20 l=0.5
X199 SRC_BDY_HVC a_1368_5960# DRN_HVC SRC_BDY_HVC sky130_fd_pr__nfet_g5v0d10v5 ad=13.9 pd=41.39 as=15.1 ps=21.51 w=20 l=0.5
X200 SRC_BDY_HVC a_1368_5960# DRN_HVC SRC_BDY_HVC sky130_fd_pr__nfet_g5v0d10v5 ad=13.9 pd=41.39 as=15.1 ps=21.51 w=20 l=0.5
X201 SRC_BDY_HVC a_1368_5960# DRN_HVC SRC_BDY_HVC sky130_fd_pr__nfet_g5v0d10v5 ad=13.9 pd=41.39 as=15.1 ps=21.51 w=20 l=0.5
X202 SRC_BDY_HVC a_1368_5960# DRN_HVC SRC_BDY_HVC sky130_fd_pr__nfet_g5v0d10v5 ad=13.9 pd=41.39 as=15.1 ps=21.51 w=20 l=0.5
X203 DRN_HVC a_1368_5960# SRC_BDY_HVC SRC_BDY_HVC sky130_fd_pr__nfet_g5v0d10v5 ad=7.55 pd=11.51 as=6.95 ps=21.39 w=10 l=0.5
X204 SRC_BDY_HVC a_1368_5960# DRN_HVC SRC_BDY_HVC sky130_fd_pr__nfet_g5v0d10v5 ad=13.9 pd=41.39 as=15.1 ps=21.51 w=20 l=0.5
X205 a_1368_5960# a_1268_5934# SRC_BDY_HVC SRC_BDY_HVC sky130_fd_pr__nfet_g5v0d10v5 ad=1.855 pd=14.53 as=0.98 ps=7.28 w=7 l=0.5
X206 a_1368_5960# a_1268_5934# DRN_HVC DRN_HVC sky130_fd_pr__pfet_g5v0d10v5 ad=0.98 pd=7.28 as=0.98 ps=7.28 w=7 l=0.5
X207 SRC_BDY_HVC a_1268_5934# a_1368_5960# SRC_BDY_HVC sky130_fd_pr__nfet_g5v0d10v5 ad=0.98 pd=7.28 as=0.98 ps=7.28 w=7 l=0.5
X208 DRN_HVC a_1268_5934# a_1368_5960# DRN_HVC sky130_fd_pr__pfet_g5v0d10v5 ad=0.98 pd=7.28 as=0.98 ps=7.28 w=7 l=0.5
X209 DRN_HVC a_1368_5960# SRC_BDY_HVC SRC_BDY_HVC sky130_fd_pr__nfet_g5v0d10v5 ad=15.1 pd=21.51 as=13.9 ps=41.39 w=20 l=0.5
X210 SRC_BDY_HVC a_1368_5960# DRN_HVC SRC_BDY_HVC sky130_fd_pr__nfet_g5v0d10v5 ad=6.95 pd=21.39 as=7.55 ps=11.51 w=10 l=0.5
.ends

.subckt sky130_ef_io__vssio_hvc_pad DRN_HVC SRC_BDY_HVC VSSIO_PAD VDDA VSSD VSSA AMUXBUS_B
+ AMUXBUS_A VDDIO_Q VDDIO VSSIO VSSIO_Q VSWITCH VCCHIB VCCD
Xsky130_fd_io__top_ground_hvc_wpad_2 VCCHIB VDDA VDDIO_Q VSSIO_Q VSSIO_PAD VSSIO_Q
+ VSSIO_Q DRN_HVC SRC_BDY_HVC VDDIO VSSIO AMUXBUS_B VSSIO VDDIO VSSD VSWITCH VSSA
+ AMUXBUS_A VCCD sky130_fd_io__top_ground_hvc_wpad
.ends

.subckt chip_io dm0[0] dm0[10] dm0[11] dm0[12] dm0[13] dm0[14] dm0[15] dm0[1] dm0[2]
+ dm0[3] dm0[4] dm0[5] dm0[6] dm0[7] dm0[8] dm0[9] dm1[0] dm1[10] dm1[11] dm1[12]
+ dm1[13] dm1[14] dm1[15] dm1[1] dm1[2] dm1[3] dm1[4] dm1[5] dm1[6] dm1[7] dm1[8]
+ dm1[9] dm2[0] dm2[10] dm2[11] dm2[12] dm2[13] dm2[14] dm2[15] dm2[1] dm2[2] dm2[3]
+ dm2[4] dm2[5] dm2[6] dm2[7] dm2[8] dm2[9] gpio_in[0] gpio_in[10] gpio_in[11] gpio_in[12]
+ gpio_in[13] gpio_in[14] gpio_in[15] gpio_in[1] gpio_in[2] gpio_in[3] gpio_in[4]
+ gpio_in[5] gpio_in[6] gpio_in[7] gpio_in[8] gpio_in[9] gpio_out[0] gpio_out[10]
+ gpio_out[11] gpio_out[12] gpio_out[13] gpio_out[14] gpio_out[15] gpio_out[1] gpio_out[2]
+ gpio_out[3] gpio_out[4] gpio_out[5] gpio_out[6] gpio_out[7] gpio_out[8] gpio_out[9]
+ gpio_pad[0] gpio_pad[10] gpio_pad[11] gpio_pad[12] gpio_pad[13] gpio_pad[14] gpio_pad[15]
+ gpio_pad[1] gpio_pad[2] gpio_pad[3] gpio_pad[4] gpio_pad[5] gpio_pad[6] gpio_pad[7]
+ gpio_pad[8] gpio_pad[9] hld_ovr[0] hld_ovr[10] hld_ovr[11] hld_ovr[12] hld_ovr[13]
+ hld_ovr[14] hld_ovr[15] hld_ovr[1] hld_ovr[2] hld_ovr[3] hld_ovr[4] hld_ovr[5] hld_ovr[6]
+ hld_ovr[7] hld_ovr[8] hld_ovr[9] ib_mode_sel[0] ib_mode_sel[10] ib_mode_sel[11]
+ ib_mode_sel[12] ib_mode_sel[13] ib_mode_sel[14] ib_mode_sel[15] ib_mode_sel[1] ib_mode_sel[2]
+ ib_mode_sel[3] ib_mode_sel[4] ib_mode_sel[5] ib_mode_sel[6] ib_mode_sel[7] ib_mode_sel[8]
+ ib_mode_sel[9] oe_n[0] oe_n[10] oe_n[11] oe_n[12] oe_n[13] oe_n[14] oe_n[15] oe_n[1]
+ oe_n[2] oe_n[3] oe_n[4] oe_n[5] oe_n[6] oe_n[7] oe_n[8] oe_n[9] por porb_h vccd
+ vddio vssd vssio
Xgpio_pads\[4\].u_gpio_pad gpio_pads\[4\].u_gpio_pad/IN_H gpio_pads\[4\].u_gpio_pad/PAD_A_NOESD_H
+ gpio_pads\[4\].u_gpio_pad/PAD_A_ESD_0_H gpio_pads\[4\].u_gpio_pad/PAD_A_ESD_1_H
+ dm2[4] dm1[4] dm0[4] gpio_pads\[4\].u_gpio_pad/HLD_H_N gpio_in[4] por ib_mode_sel[4]
+ porb_h porb_h gpio_pads\[4\].u_gpio_pad/ENABLE_INP_H oe_n[4] gpio_pads\[4\].u_gpio_pad/TIE_HI_ESD
+ gpio_pads\[4\].u_gpio_pad/TIE_LO_ESD gpio_pads\[4\].u_gpio_pad/SLOW gpio_pads\[4\].u_gpio_pad/VTRIP_SEL
+ hld_ovr[4] gpio_pads\[4\].u_gpio_pad/ANALOG_EN gpio_pads\[4\].u_gpio_pad/ANALOG_SEL
+ gpio_pads\[4\].u_gpio_pad/ENABLE_VDDIO gpio_pads\[4\].u_gpio_pad/ENABLE_VSWITCH_H
+ gpio_pads\[4\].u_gpio_pad/ANALOG_POL gpio_out[4] vssd/VDDIO_Q w_21151_156870# vssd/VSSIO_Q
+ w_21253_153552# vccd vssd/AMUXBUS_B vssd/AMUXBUS_A vssio vssd/VSWITCH vssd/VDDA
+ w_23367_153552# vddio vssd/VSSA w_23367_156869# vssd gpio_pad[4] vssd/VCCHIB sky130_ef_io__gpiov2_pad_wrapped
Xvssd vssd/DRN_LVC1 vssd/DRN_LVC2 vssd/BDY2_B2B vssd/VSSD_PAD vssd/VDDA vssd/SRC_BDY_LVC2
+ vccd vssd/SRC_BDY_LVC1 vssd/VSWITCH vddio vssd/AMUXBUS_B vssd/AMUXBUS_A vssd/VDDIO_Q
+ vssd vssio vssd/VCCHIB vssd/VSSIO_Q vssd/VSSA sky130_ef_io__vssd_lvc_pad
Xgpio_pads\[9\].u_gpio_pad gpio_pads\[9\].u_gpio_pad/IN_H gpio_pads\[9\].u_gpio_pad/PAD_A_NOESD_H
+ gpio_pads\[9\].u_gpio_pad/PAD_A_ESD_0_H gpio_pads\[9\].u_gpio_pad/PAD_A_ESD_1_H
+ dm2[9] dm1[9] dm0[9] gpio_pads\[9\].u_gpio_pad/HLD_H_N gpio_in[9] por ib_mode_sel[9]
+ porb_h porb_h gpio_pads\[9\].u_gpio_pad/ENABLE_INP_H oe_n[9] gpio_pads\[9\].u_gpio_pad/TIE_HI_ESD
+ gpio_pads\[9\].u_gpio_pad/TIE_LO_ESD gpio_pads\[9\].u_gpio_pad/SLOW gpio_pads\[9\].u_gpio_pad/VTRIP_SEL
+ hld_ovr[9] gpio_pads\[9\].u_gpio_pad/ANALOG_EN gpio_pads\[9\].u_gpio_pad/ANALOG_SEL
+ gpio_pads\[9\].u_gpio_pad/ENABLE_VDDIO gpio_pads\[9\].u_gpio_pad/ENABLE_VSWITCH_H
+ gpio_pads\[9\].u_gpio_pad/ANALOG_POL gpio_out[9] vssd/VDDIO_Q w_376869_267069# vssd/VSSIO_Q
+ w_376869_263752# vccd vssd/AMUXBUS_B vssd/AMUXBUS_A vssio vssd/VSWITCH vssd/VDDA
+ w_374755_263752# vddio vssd/VSSA w_374653_267070# vssd gpio_pad[9] vssd/VCCHIB sky130_ef_io__gpiov2_pad_wrapped
Xgpio_pads\[13\].u_gpio_pad gpio_pads\[13\].u_gpio_pad/IN_H gpio_pads\[13\].u_gpio_pad/PAD_A_NOESD_H
+ gpio_pads\[13\].u_gpio_pad/PAD_A_ESD_0_H gpio_pads\[13\].u_gpio_pad/PAD_A_ESD_1_H
+ dm2[13] dm1[13] dm0[13] gpio_pads\[13\].u_gpio_pad/HLD_H_N gpio_in[13] por ib_mode_sel[13]
+ porb_h porb_h gpio_pads\[13\].u_gpio_pad/ENABLE_INP_H oe_n[13] gpio_pads\[13\].u_gpio_pad/TIE_HI_ESD
+ gpio_pads\[13\].u_gpio_pad/TIE_LO_ESD gpio_pads\[13\].u_gpio_pad/SLOW gpio_pads\[13\].u_gpio_pad/VTRIP_SEL
+ hld_ovr[13] gpio_pads\[13\].u_gpio_pad/ANALOG_EN gpio_pads\[13\].u_gpio_pad/ANALOG_SEL
+ gpio_pads\[13\].u_gpio_pad/ENABLE_VDDIO gpio_pads\[13\].u_gpio_pad/ENABLE_VSWITCH_H
+ gpio_pads\[13\].u_gpio_pad/ANALOG_POL gpio_out[13] vssd/VDDIO_Q w_376869_114469#
+ vssd/VSSIO_Q w_376869_111152# vccd vssd/AMUXBUS_B vssd/AMUXBUS_A vssio vssd/VSWITCH
+ vssd/VDDA w_374755_111152# vddio vssd/VSSA w_374653_114470# vssd gpio_pad[13] vssd/VCCHIB
+ sky130_ef_io__gpiov2_pad_wrapped
Xu_vddio_pad u_vddio_pad/DRN_HVC u_vddio_pad/VDDIO_PAD vssd/VDDA vssd/VSSIO_Q vddio
+ vssio vssd/VDDIO_Q vssd vssd/AMUXBUS_B vssd/VSSA vssd/AMUXBUS_A vssd/VSWITCH vssd/VCCHIB
+ u_vddio_pad/SRC_BDY_HVC vccd sky130_ef_io__vddio_hvc_pad
Xvccd vccd/DRN_LVC1 vccd/DRN_LVC2 vccd/SRC_BDY_LVC1 vccd/SRC_BDY_LVC2 vccd/BDY2_B2B
+ vccd/VCCD_PAD vssd/VDDA vssd/VCCHIB vssd/AMUXBUS_B vssd/AMUXBUS_A vccd vddio vssd
+ vssio vssd/VDDIO_Q vssd/VSWITCH vssd/VSSA vssd/VSSIO_Q sky130_ef_io__vccd_lvc_pad
Xgpio_pads\[0\].u_gpio_pad gpio_pads\[0\].u_gpio_pad/IN_H gpio_pads\[0\].u_gpio_pad/PAD_A_NOESD_H
+ gpio_pads\[0\].u_gpio_pad/PAD_A_ESD_0_H gpio_pads\[0\].u_gpio_pad/PAD_A_ESD_1_H
+ dm2[0] dm1[0] dm0[0] gpio_pads\[0\].u_gpio_pad/HLD_H_N gpio_in[0] por ib_mode_sel[0]
+ porb_h porb_h gpio_pads\[0\].u_gpio_pad/ENABLE_INP_H oe_n[0] gpio_pads\[0\].u_gpio_pad/TIE_HI_ESD
+ gpio_pads\[0\].u_gpio_pad/TIE_LO_ESD gpio_pads\[0\].u_gpio_pad/SLOW gpio_pads\[0\].u_gpio_pad/VTRIP_SEL
+ hld_ovr[0] gpio_pads\[0\].u_gpio_pad/ANALOG_EN gpio_pads\[0\].u_gpio_pad/ANALOG_SEL
+ gpio_pads\[0\].u_gpio_pad/ENABLE_VDDIO gpio_pads\[0\].u_gpio_pad/ENABLE_VSWITCH_H
+ gpio_pads\[0\].u_gpio_pad/ANALOG_POL gpio_out[0] vssd/VDDIO_Q w_21151_281270# vssd/VSSIO_Q
+ w_21253_277952# vccd vssd/AMUXBUS_B vssd/AMUXBUS_A vssio vssd/VSWITCH vssd/VDDA
+ w_23367_277952# vddio vssd/VSSA w_23367_281269# vssd gpio_pad[0] vssd/VCCHIB sky130_ef_io__gpiov2_pad_wrapped
Xgpio_pads\[5\].u_gpio_pad gpio_pads\[5\].u_gpio_pad/IN_H gpio_pads\[5\].u_gpio_pad/PAD_A_NOESD_H
+ gpio_pads\[5\].u_gpio_pad/PAD_A_ESD_0_H gpio_pads\[5\].u_gpio_pad/PAD_A_ESD_1_H
+ dm2[5] dm1[5] dm0[5] gpio_pads\[5\].u_gpio_pad/HLD_H_N gpio_in[5] por ib_mode_sel[5]
+ porb_h porb_h gpio_pads\[5\].u_gpio_pad/ENABLE_INP_H oe_n[5] gpio_pads\[5\].u_gpio_pad/TIE_HI_ESD
+ gpio_pads\[5\].u_gpio_pad/TIE_LO_ESD gpio_pads\[5\].u_gpio_pad/SLOW gpio_pads\[5\].u_gpio_pad/VTRIP_SEL
+ hld_ovr[5] gpio_pads\[5\].u_gpio_pad/ANALOG_EN gpio_pads\[5\].u_gpio_pad/ANALOG_SEL
+ gpio_pads\[5\].u_gpio_pad/ENABLE_VDDIO gpio_pads\[5\].u_gpio_pad/ENABLE_VSWITCH_H
+ gpio_pads\[5\].u_gpio_pad/ANALOG_POL gpio_out[5] vssd/VDDIO_Q w_21151_125670# vssd/VSSIO_Q
+ w_21253_122352# vccd vssd/AMUXBUS_B vssd/AMUXBUS_A vssio vssd/VSWITCH vssd/VDDA
+ w_23367_122352# vddio vssd/VSSA w_23367_125669# vssd gpio_pad[5] vssd/VCCHIB sky130_ef_io__gpiov2_pad_wrapped
Xu_vssio_pad u_vssio_pad/DRN_HVC u_vssio_pad/SRC_BDY_HVC u_vssio_pad/VSSIO_PAD vssd/VDDA
+ vssd vssd/VSSA vssd/AMUXBUS_B vssd/AMUXBUS_A vssd/VDDIO_Q vddio vssio vssd/VSSIO_Q
+ vssd/VSWITCH vssd/VCCHIB vccd sky130_ef_io__vssio_hvc_pad
Xgpio_pads\[14\].u_gpio_pad gpio_pads\[14\].u_gpio_pad/IN_H gpio_pads\[14\].u_gpio_pad/PAD_A_NOESD_H
+ gpio_pads\[14\].u_gpio_pad/PAD_A_ESD_0_H gpio_pads\[14\].u_gpio_pad/PAD_A_ESD_1_H
+ dm2[14] dm1[14] dm0[14] gpio_pads\[14\].u_gpio_pad/HLD_H_N gpio_in[14] por ib_mode_sel[14]
+ porb_h porb_h gpio_pads\[14\].u_gpio_pad/ENABLE_INP_H oe_n[14] gpio_pads\[14\].u_gpio_pad/TIE_HI_ESD
+ gpio_pads\[14\].u_gpio_pad/TIE_LO_ESD gpio_pads\[14\].u_gpio_pad/SLOW gpio_pads\[14\].u_gpio_pad/VTRIP_SEL
+ hld_ovr[14] gpio_pads\[14\].u_gpio_pad/ANALOG_EN gpio_pads\[14\].u_gpio_pad/ANALOG_SEL
+ gpio_pads\[14\].u_gpio_pad/ENABLE_VDDIO gpio_pads\[14\].u_gpio_pad/ENABLE_VSWITCH_H
+ gpio_pads\[14\].u_gpio_pad/ANALOG_POL gpio_out[14] vssd/VDDIO_Q w_376869_88869#
+ vssd/VSSIO_Q w_376869_85552# vccd vssd/AMUXBUS_B vssd/AMUXBUS_A vssio vssd/VSWITCH
+ vssd/VDDA w_374755_85552# vddio vssd/VSSA w_374653_88870# vssd gpio_pad[14] vssd/VCCHIB
+ sky130_ef_io__gpiov2_pad_wrapped
Xu_vccd_pad u_vccd_pad/DRN_LVC1 u_vccd_pad/DRN_LVC2 u_vccd_pad/SRC_BDY_LVC1 u_vccd_pad/SRC_BDY_LVC2
+ u_vccd_pad/BDY2_B2B u_vccd_pad/VCCD_PAD vssd/VDDA vssd/VCCHIB vssd/AMUXBUS_B vssd/AMUXBUS_A
+ vccd vddio vssd vssio vssd/VDDIO_Q vssd/VSWITCH vssd/VSSA vssd/VSSIO_Q sky130_ef_io__vccd_lvc_pad
Xgpio_pads\[1\].u_gpio_pad gpio_pads\[1\].u_gpio_pad/IN_H gpio_pads\[1\].u_gpio_pad/PAD_A_NOESD_H
+ gpio_pads\[1\].u_gpio_pad/PAD_A_ESD_0_H gpio_pads\[1\].u_gpio_pad/PAD_A_ESD_1_H
+ dm2[1] dm1[1] dm0[1] gpio_pads\[1\].u_gpio_pad/HLD_H_N gpio_in[1] por ib_mode_sel[1]
+ porb_h porb_h gpio_pads\[1\].u_gpio_pad/ENABLE_INP_H oe_n[1] gpio_pads\[1\].u_gpio_pad/TIE_HI_ESD
+ gpio_pads\[1\].u_gpio_pad/TIE_LO_ESD gpio_pads\[1\].u_gpio_pad/SLOW gpio_pads\[1\].u_gpio_pad/VTRIP_SEL
+ hld_ovr[1] gpio_pads\[1\].u_gpio_pad/ANALOG_EN gpio_pads\[1\].u_gpio_pad/ANALOG_SEL
+ gpio_pads\[1\].u_gpio_pad/ENABLE_VDDIO gpio_pads\[1\].u_gpio_pad/ENABLE_VSWITCH_H
+ gpio_pads\[1\].u_gpio_pad/ANALOG_POL gpio_out[1] vssd/VDDIO_Q w_21151_250070# vssd/VSSIO_Q
+ w_21253_246752# vccd vssd/AMUXBUS_B vssd/AMUXBUS_A vssio vssd/VSWITCH vssd/VDDA
+ w_23367_246752# vddio vssd/VSSA w_23367_250069# vssd gpio_pad[1] vssd/VCCHIB sky130_ef_io__gpiov2_pad_wrapped
Xgpio_pads\[6\].u_gpio_pad gpio_pads\[6\].u_gpio_pad/IN_H gpio_pads\[6\].u_gpio_pad/PAD_A_NOESD_H
+ gpio_pads\[6\].u_gpio_pad/PAD_A_ESD_0_H gpio_pads\[6\].u_gpio_pad/PAD_A_ESD_1_H
+ dm2[6] dm1[6] dm0[6] gpio_pads\[6\].u_gpio_pad/HLD_H_N gpio_in[6] por ib_mode_sel[6]
+ porb_h porb_h gpio_pads\[6\].u_gpio_pad/ENABLE_INP_H oe_n[6] gpio_pads\[6\].u_gpio_pad/TIE_HI_ESD
+ gpio_pads\[6\].u_gpio_pad/TIE_LO_ESD gpio_pads\[6\].u_gpio_pad/SLOW gpio_pads\[6\].u_gpio_pad/VTRIP_SEL
+ hld_ovr[6] gpio_pads\[6\].u_gpio_pad/ANALOG_EN gpio_pads\[6\].u_gpio_pad/ANALOG_SEL
+ gpio_pads\[6\].u_gpio_pad/ENABLE_VDDIO gpio_pads\[6\].u_gpio_pad/ENABLE_VSWITCH_H
+ gpio_pads\[6\].u_gpio_pad/ANALOG_POL gpio_out[6] vssd/VDDIO_Q w_21151_94670# vssd/VSSIO_Q
+ w_21253_91352# vccd vssd/AMUXBUS_B vssd/AMUXBUS_A vssio vssd/VSWITCH vssd/VDDA w_23367_91352#
+ vddio vssd/VSSA w_23367_94669# vssd gpio_pad[6] vssd/VCCHIB sky130_ef_io__gpiov2_pad_wrapped
Xgpio_pads\[10\].u_gpio_pad gpio_pads\[10\].u_gpio_pad/IN_H gpio_pads\[10\].u_gpio_pad/PAD_A_NOESD_H
+ gpio_pads\[10\].u_gpio_pad/PAD_A_ESD_0_H gpio_pads\[10\].u_gpio_pad/PAD_A_ESD_1_H
+ dm2[10] dm1[10] dm0[10] gpio_pads\[10\].u_gpio_pad/HLD_H_N gpio_in[10] por ib_mode_sel[10]
+ porb_h porb_h gpio_pads\[10\].u_gpio_pad/ENABLE_INP_H oe_n[10] gpio_pads\[10\].u_gpio_pad/TIE_HI_ESD
+ gpio_pads\[10\].u_gpio_pad/TIE_LO_ESD gpio_pads\[10\].u_gpio_pad/SLOW gpio_pads\[10\].u_gpio_pad/VTRIP_SEL
+ hld_ovr[10] gpio_pads\[10\].u_gpio_pad/ANALOG_EN gpio_pads\[10\].u_gpio_pad/ANALOG_SEL
+ gpio_pads\[10\].u_gpio_pad/ENABLE_VDDIO gpio_pads\[10\].u_gpio_pad/ENABLE_VSWITCH_H
+ gpio_pads\[10\].u_gpio_pad/ANALOG_POL gpio_out[10] vssd/VDDIO_Q w_376869_241669#
+ vssd/VSSIO_Q w_376869_238352# vccd vssd/AMUXBUS_B vssd/AMUXBUS_A vssio vssd/VSWITCH
+ vssd/VDDA w_374755_238352# vddio vssd/VSSA w_374653_241670# vssd gpio_pad[10] vssd/VCCHIB
+ sky130_ef_io__gpiov2_pad_wrapped
Xgpio_pads\[15\].u_gpio_pad gpio_pads\[15\].u_gpio_pad/IN_H gpio_pads\[15\].u_gpio_pad/PAD_A_NOESD_H
+ gpio_pads\[15\].u_gpio_pad/PAD_A_ESD_0_H gpio_pads\[15\].u_gpio_pad/PAD_A_ESD_1_H
+ dm2[15] dm1[15] dm0[15] gpio_pads\[15\].u_gpio_pad/HLD_H_N gpio_in[15] por ib_mode_sel[15]
+ porb_h porb_h gpio_pads\[15\].u_gpio_pad/ENABLE_INP_H oe_n[15] gpio_pads\[15\].u_gpio_pad/TIE_HI_ESD
+ gpio_pads\[15\].u_gpio_pad/TIE_LO_ESD gpio_pads\[15\].u_gpio_pad/SLOW gpio_pads\[15\].u_gpio_pad/VTRIP_SEL
+ hld_ovr[15] gpio_pads\[15\].u_gpio_pad/ANALOG_EN gpio_pads\[15\].u_gpio_pad/ANALOG_SEL
+ gpio_pads\[15\].u_gpio_pad/ENABLE_VDDIO gpio_pads\[15\].u_gpio_pad/ENABLE_VSWITCH_H
+ gpio_pads\[15\].u_gpio_pad/ANALOG_POL gpio_out[15] vssd/VDDIO_Q w_376869_63469#
+ vssd/VSSIO_Q w_376869_60152# vccd vssd/AMUXBUS_B vssd/AMUXBUS_A vssio vssd/VSWITCH
+ vssd/VDDA w_374755_60152# vddio vssd/VSSA w_374653_63470# vssd gpio_pad[15] vssd/VCCHIB
+ sky130_ef_io__gpiov2_pad_wrapped
Xgpio_pads\[2\].u_gpio_pad gpio_pads\[2\].u_gpio_pad/IN_H gpio_pads\[2\].u_gpio_pad/PAD_A_NOESD_H
+ gpio_pads\[2\].u_gpio_pad/PAD_A_ESD_0_H gpio_pads\[2\].u_gpio_pad/PAD_A_ESD_1_H
+ dm2[2] dm1[2] dm0[2] gpio_pads\[2\].u_gpio_pad/HLD_H_N gpio_in[2] por ib_mode_sel[2]
+ porb_h porb_h gpio_pads\[2\].u_gpio_pad/ENABLE_INP_H oe_n[2] gpio_pads\[2\].u_gpio_pad/TIE_HI_ESD
+ gpio_pads\[2\].u_gpio_pad/TIE_LO_ESD gpio_pads\[2\].u_gpio_pad/SLOW gpio_pads\[2\].u_gpio_pad/VTRIP_SEL
+ hld_ovr[2] gpio_pads\[2\].u_gpio_pad/ANALOG_EN gpio_pads\[2\].u_gpio_pad/ANALOG_SEL
+ gpio_pads\[2\].u_gpio_pad/ENABLE_VDDIO gpio_pads\[2\].u_gpio_pad/ENABLE_VSWITCH_H
+ gpio_pads\[2\].u_gpio_pad/ANALOG_POL gpio_out[2] vssd/VDDIO_Q w_21151_219070# vssd/VSSIO_Q
+ w_21253_215752# vccd vssd/AMUXBUS_B vssd/AMUXBUS_A vssio vssd/VSWITCH vssd/VDDA
+ w_23367_215752# vddio vssd/VSSA w_23367_219069# vssd gpio_pad[2] vssd/VCCHIB sky130_ef_io__gpiov2_pad_wrapped
Xgpio_pads\[7\].u_gpio_pad gpio_pads\[7\].u_gpio_pad/IN_H gpio_pads\[7\].u_gpio_pad/PAD_A_NOESD_H
+ gpio_pads\[7\].u_gpio_pad/PAD_A_ESD_0_H gpio_pads\[7\].u_gpio_pad/PAD_A_ESD_1_H
+ dm2[7] dm1[7] dm0[7] gpio_pads\[7\].u_gpio_pad/HLD_H_N gpio_in[7] por ib_mode_sel[7]
+ porb_h porb_h gpio_pads\[7\].u_gpio_pad/ENABLE_INP_H oe_n[7] gpio_pads\[7\].u_gpio_pad/TIE_HI_ESD
+ gpio_pads\[7\].u_gpio_pad/TIE_LO_ESD gpio_pads\[7\].u_gpio_pad/SLOW gpio_pads\[7\].u_gpio_pad/VTRIP_SEL
+ hld_ovr[7] gpio_pads\[7\].u_gpio_pad/ANALOG_EN gpio_pads\[7\].u_gpio_pad/ANALOG_SEL
+ gpio_pads\[7\].u_gpio_pad/ENABLE_VDDIO gpio_pads\[7\].u_gpio_pad/ENABLE_VSWITCH_H
+ gpio_pads\[7\].u_gpio_pad/ANALOG_POL gpio_out[7] vssd/VDDIO_Q w_21151_63470# vssd/VSSIO_Q
+ w_21253_60152# vccd vssd/AMUXBUS_B vssd/AMUXBUS_A vssio vssd/VSWITCH vssd/VDDA w_23367_60152#
+ vddio vssd/VSSA w_23367_63469# vssd gpio_pad[7] vssd/VCCHIB sky130_ef_io__gpiov2_pad_wrapped
Xgpio_pads\[11\].u_gpio_pad gpio_pads\[11\].u_gpio_pad/IN_H gpio_pads\[11\].u_gpio_pad/PAD_A_NOESD_H
+ gpio_pads\[11\].u_gpio_pad/PAD_A_ESD_0_H gpio_pads\[11\].u_gpio_pad/PAD_A_ESD_1_H
+ dm2[11] dm1[11] dm0[11] gpio_pads\[11\].u_gpio_pad/HLD_H_N gpio_in[11] por ib_mode_sel[11]
+ porb_h porb_h gpio_pads\[11\].u_gpio_pad/ENABLE_INP_H oe_n[11] gpio_pads\[11\].u_gpio_pad/TIE_HI_ESD
+ gpio_pads\[11\].u_gpio_pad/TIE_LO_ESD gpio_pads\[11\].u_gpio_pad/SLOW gpio_pads\[11\].u_gpio_pad/VTRIP_SEL
+ hld_ovr[11] gpio_pads\[11\].u_gpio_pad/ANALOG_EN gpio_pads\[11\].u_gpio_pad/ANALOG_SEL
+ gpio_pads\[11\].u_gpio_pad/ENABLE_VDDIO gpio_pads\[11\].u_gpio_pad/ENABLE_VSWITCH_H
+ gpio_pads\[11\].u_gpio_pad/ANALOG_POL gpio_out[11] vssd/VDDIO_Q w_376869_216269#
+ vssd/VSSIO_Q w_376869_212952# vccd vssd/AMUXBUS_B vssd/AMUXBUS_A vssio vssd/VSWITCH
+ vssd/VDDA w_374755_212952# vddio vssd/VSSA w_374653_216270# vssd gpio_pad[11] vssd/VCCHIB
+ sky130_ef_io__gpiov2_pad_wrapped
Xgpio_pads\[3\].u_gpio_pad gpio_pads\[3\].u_gpio_pad/IN_H gpio_pads\[3\].u_gpio_pad/PAD_A_NOESD_H
+ gpio_pads\[3\].u_gpio_pad/PAD_A_ESD_0_H gpio_pads\[3\].u_gpio_pad/PAD_A_ESD_1_H
+ dm2[3] dm1[3] dm0[3] gpio_pads\[3\].u_gpio_pad/HLD_H_N gpio_in[3] por ib_mode_sel[3]
+ porb_h porb_h gpio_pads\[3\].u_gpio_pad/ENABLE_INP_H oe_n[3] gpio_pads\[3\].u_gpio_pad/TIE_HI_ESD
+ gpio_pads\[3\].u_gpio_pad/TIE_LO_ESD gpio_pads\[3\].u_gpio_pad/SLOW gpio_pads\[3\].u_gpio_pad/VTRIP_SEL
+ hld_ovr[3] gpio_pads\[3\].u_gpio_pad/ANALOG_EN gpio_pads\[3\].u_gpio_pad/ANALOG_SEL
+ gpio_pads\[3\].u_gpio_pad/ENABLE_VDDIO gpio_pads\[3\].u_gpio_pad/ENABLE_VSWITCH_H
+ gpio_pads\[3\].u_gpio_pad/ANALOG_POL gpio_out[3] vssd/VDDIO_Q w_21151_187870# vssd/VSSIO_Q
+ w_21253_184552# vccd vssd/AMUXBUS_B vssd/AMUXBUS_A vssio vssd/VSWITCH vssd/VDDA
+ w_23367_184552# vddio vssd/VSSA w_23367_187869# vssd gpio_pad[3] vssd/VCCHIB sky130_ef_io__gpiov2_pad_wrapped
Xgpio_pads\[8\].u_gpio_pad gpio_pads\[8\].u_gpio_pad/IN_H gpio_pads\[8\].u_gpio_pad/PAD_A_NOESD_H
+ gpio_pads\[8\].u_gpio_pad/PAD_A_ESD_0_H gpio_pads\[8\].u_gpio_pad/PAD_A_ESD_1_H
+ dm2[8] dm1[8] dm0[8] gpio_pads\[8\].u_gpio_pad/HLD_H_N gpio_in[8] por ib_mode_sel[8]
+ porb_h porb_h gpio_pads\[8\].u_gpio_pad/ENABLE_INP_H oe_n[8] gpio_pads\[8\].u_gpio_pad/TIE_HI_ESD
+ gpio_pads\[8\].u_gpio_pad/TIE_LO_ESD gpio_pads\[8\].u_gpio_pad/SLOW gpio_pads\[8\].u_gpio_pad/VTRIP_SEL
+ hld_ovr[8] gpio_pads\[8\].u_gpio_pad/ANALOG_EN gpio_pads\[8\].u_gpio_pad/ANALOG_SEL
+ gpio_pads\[8\].u_gpio_pad/ENABLE_VDDIO gpio_pads\[8\].u_gpio_pad/ENABLE_VSWITCH_H
+ gpio_pads\[8\].u_gpio_pad/ANALOG_POL gpio_out[8] vssd/VDDIO_Q w_376869_292469# vssd/VSSIO_Q
+ w_376869_289152# vccd vssd/AMUXBUS_B vssd/AMUXBUS_A vssio vssd/VSWITCH vssd/VDDA
+ w_374755_289152# vddio vssd/VSSA w_374653_292470# vssd gpio_pad[8] vssd/VCCHIB sky130_ef_io__gpiov2_pad_wrapped
Xu_vssd_pad u_vssd_pad/DRN_LVC1 u_vssd_pad/DRN_LVC2 u_vssd_pad/BDY2_B2B u_vssd_pad/VSSD_PAD
+ vssd/VDDA u_vssd_pad/SRC_BDY_LVC2 vccd u_vssd_pad/SRC_BDY_LVC1 vssd/VSWITCH vddio
+ vssd/AMUXBUS_B vssd/AMUXBUS_A vssd/VDDIO_Q vssd vssio vssd/VCCHIB vssd/VSSIO_Q vssd/VSSA
+ sky130_ef_io__vssd_lvc_pad
Xgpio_pads\[12\].u_gpio_pad gpio_pads\[12\].u_gpio_pad/IN_H gpio_pads\[12\].u_gpio_pad/PAD_A_NOESD_H
+ gpio_pads\[12\].u_gpio_pad/PAD_A_ESD_0_H gpio_pads\[12\].u_gpio_pad/PAD_A_ESD_1_H
+ dm2[12] dm1[12] dm0[12] gpio_pads\[12\].u_gpio_pad/HLD_H_N gpio_in[12] por ib_mode_sel[12]
+ porb_h porb_h gpio_pads\[12\].u_gpio_pad/ENABLE_INP_H oe_n[12] gpio_pads\[12\].u_gpio_pad/TIE_HI_ESD
+ gpio_pads\[12\].u_gpio_pad/TIE_LO_ESD gpio_pads\[12\].u_gpio_pad/SLOW gpio_pads\[12\].u_gpio_pad/VTRIP_SEL
+ hld_ovr[12] gpio_pads\[12\].u_gpio_pad/ANALOG_EN gpio_pads\[12\].u_gpio_pad/ANALOG_SEL
+ gpio_pads\[12\].u_gpio_pad/ENABLE_VDDIO gpio_pads\[12\].u_gpio_pad/ENABLE_VSWITCH_H
+ gpio_pads\[12\].u_gpio_pad/ANALOG_POL gpio_out[12] vssd/VDDIO_Q w_376869_139869#
+ vssd/VSSIO_Q w_376869_136552# vccd vssd/AMUXBUS_B vssd/AMUXBUS_A vssio vssd/VSWITCH
+ vssd/VDDA w_374755_136552# vddio vssd/VSSA w_374653_139870# vssd gpio_pad[12] vssd/VCCHIB
+ sky130_ef_io__gpiov2_pad_wrapped
.ends
